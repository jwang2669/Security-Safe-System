* NGSPICE file created from SSS.ext - technology: sky130A

* Black-box entry subcircuit for sky130_fd_sc_hd__tapvpwrvgnd_1 abstract view
.subckt sky130_fd_sc_hd__tapvpwrvgnd_1 VGND VPWR
.ends

* Black-box entry subcircuit for sky130_fd_sc_hd__decap_3 abstract view
.subckt sky130_fd_sc_hd__decap_3 VGND VNB VPB VPWR
.ends

* Black-box entry subcircuit for sky130_fd_sc_hd__and2_1 abstract view
.subckt sky130_fd_sc_hd__and2_1 A B VGND VNB VPB VPWR X
.ends

* Black-box entry subcircuit for sky130_fd_sc_hd__decap_8 abstract view
.subckt sky130_fd_sc_hd__decap_8 VGND VNB VPB VPWR
.ends

* Black-box entry subcircuit for sky130_ef_sc_hd__decap_12 abstract view
.subckt sky130_ef_sc_hd__decap_12 VPWR VGND VPB VNB
.ends

* Black-box entry subcircuit for sky130_fd_sc_hd__nand2_2 abstract view
.subckt sky130_fd_sc_hd__nand2_2 A B VGND VNB VPB VPWR Y
.ends

* Black-box entry subcircuit for sky130_fd_sc_hd__nand2b_1 abstract view
.subckt sky130_fd_sc_hd__nand2b_1 A_N B VGND VNB VPB VPWR Y
.ends

* Black-box entry subcircuit for sky130_fd_sc_hd__fill_1 abstract view
.subckt sky130_fd_sc_hd__fill_1 VGND VNB VPB VPWR
.ends

* Black-box entry subcircuit for sky130_fd_sc_hd__decap_6 abstract view
.subckt sky130_fd_sc_hd__decap_6 VGND VNB VPB VPWR
.ends

* Black-box entry subcircuit for sky130_fd_sc_hd__decap_4 abstract view
.subckt sky130_fd_sc_hd__decap_4 VGND VNB VPB VPWR
.ends

* Black-box entry subcircuit for sky130_fd_sc_hd__or4b_1 abstract view
.subckt sky130_fd_sc_hd__or4b_1 A B C D_N VGND VNB VPB VPWR X
.ends

* Black-box entry subcircuit for sky130_fd_sc_hd__a31o_1 abstract view
.subckt sky130_fd_sc_hd__a31o_1 A1 A2 A3 B1 VGND VNB VPB VPWR X
.ends

* Black-box entry subcircuit for sky130_fd_sc_hd__dfrtp_1 abstract view
.subckt sky130_fd_sc_hd__dfrtp_1 CLK D RESET_B VGND VNB VPB VPWR Q
.ends

* Black-box entry subcircuit for sky130_fd_sc_hd__and3b_1 abstract view
.subckt sky130_fd_sc_hd__and3b_1 A_N B C VGND VNB VPB VPWR X
.ends

* Black-box entry subcircuit for sky130_fd_sc_hd__o21ai_1 abstract view
.subckt sky130_fd_sc_hd__o21ai_1 A1 A2 B1 VGND VNB VPB VPWR Y
.ends

* Black-box entry subcircuit for sky130_fd_sc_hd__mux2_1 abstract view
.subckt sky130_fd_sc_hd__mux2_1 A0 A1 S VGND VNB VPB VPWR X
.ends

* Black-box entry subcircuit for sky130_fd_sc_hd__buf_2 abstract view
.subckt sky130_fd_sc_hd__buf_2 A VGND VNB VPB VPWR X
.ends

* Black-box entry subcircuit for sky130_fd_sc_hd__and4_1 abstract view
.subckt sky130_fd_sc_hd__and4_1 A B C D VGND VNB VPB VPWR X
.ends

* Black-box entry subcircuit for sky130_fd_sc_hd__and3_1 abstract view
.subckt sky130_fd_sc_hd__and3_1 A B C VGND VNB VPB VPWR X
.ends

* Black-box entry subcircuit for sky130_fd_sc_hd__or4_1 abstract view
.subckt sky130_fd_sc_hd__or4_1 A B C D VGND VNB VPB VPWR X
.ends

* Black-box entry subcircuit for sky130_fd_sc_hd__a21oi_1 abstract view
.subckt sky130_fd_sc_hd__a21oi_1 A1 A2 B1 VGND VNB VPB VPWR Y
.ends

* Black-box entry subcircuit for sky130_fd_sc_hd__nand2_1 abstract view
.subckt sky130_fd_sc_hd__nand2_1 A B VGND VNB VPB VPWR Y
.ends

* Black-box entry subcircuit for sky130_fd_sc_hd__fill_2 abstract view
.subckt sky130_fd_sc_hd__fill_2 VGND VNB VPB VPWR
.ends

* Black-box entry subcircuit for sky130_fd_sc_hd__dlygate4sd3_1 abstract view
.subckt sky130_fd_sc_hd__dlygate4sd3_1 A VGND VNB VPB VPWR X
.ends

* Black-box entry subcircuit for sky130_fd_sc_hd__nor2_1 abstract view
.subckt sky130_fd_sc_hd__nor2_1 A B VGND VNB VPB VPWR Y
.ends

* Black-box entry subcircuit for sky130_fd_sc_hd__or3_1 abstract view
.subckt sky130_fd_sc_hd__or3_1 A B C VGND VNB VPB VPWR X
.ends

* Black-box entry subcircuit for sky130_fd_sc_hd__inv_2 abstract view
.subckt sky130_fd_sc_hd__inv_2 A VGND VNB VPB VPWR Y
.ends

* Black-box entry subcircuit for sky130_fd_sc_hd__or2_1 abstract view
.subckt sky130_fd_sc_hd__or2_1 A B VGND VNB VPB VPWR X
.ends

* Black-box entry subcircuit for sky130_fd_sc_hd__o31a_1 abstract view
.subckt sky130_fd_sc_hd__o31a_1 A1 A2 A3 B1 VGND VNB VPB VPWR X
.ends

* Black-box entry subcircuit for sky130_fd_sc_hd__a21o_1 abstract view
.subckt sky130_fd_sc_hd__a21o_1 A1 A2 B1 VGND VNB VPB VPWR X
.ends

* Black-box entry subcircuit for sky130_fd_sc_hd__nand4_1 abstract view
.subckt sky130_fd_sc_hd__nand4_1 A B C D VGND VNB VPB VPWR Y
.ends

* Black-box entry subcircuit for sky130_fd_sc_hd__o211a_1 abstract view
.subckt sky130_fd_sc_hd__o211a_1 A1 A2 B1 C1 VGND VNB VPB VPWR X
.ends

* Black-box entry subcircuit for sky130_fd_sc_hd__clkbuf_16 abstract view
.subckt sky130_fd_sc_hd__clkbuf_16 A VGND VNB VPB VPWR X
.ends

* Black-box entry subcircuit for sky130_fd_sc_hd__o22a_1 abstract view
.subckt sky130_fd_sc_hd__o22a_1 A1 A2 B1 B2 VGND VNB VPB VPWR X
.ends

* Black-box entry subcircuit for sky130_fd_sc_hd__clkbuf_4 abstract view
.subckt sky130_fd_sc_hd__clkbuf_4 A VGND VNB VPB VPWR X
.ends

* Black-box entry subcircuit for sky130_fd_sc_hd__a22oi_1 abstract view
.subckt sky130_fd_sc_hd__a22oi_1 A1 A2 B1 B2 VGND VNB VPB VPWR Y
.ends

* Black-box entry subcircuit for sky130_fd_sc_hd__or4bb_1 abstract view
.subckt sky130_fd_sc_hd__or4bb_1 A B C_N D_N VGND VNB VPB VPWR X
.ends

* Black-box entry subcircuit for sky130_fd_sc_hd__o31ai_1 abstract view
.subckt sky130_fd_sc_hd__o31ai_1 A1 A2 A3 B1 VGND VNB VPB VPWR Y
.ends

* Black-box entry subcircuit for sky130_fd_sc_hd__clkbuf_2 abstract view
.subckt sky130_fd_sc_hd__clkbuf_2 A VGND VNB VPB VPWR X
.ends

* Black-box entry subcircuit for sky130_fd_sc_hd__clkinv_4 abstract view
.subckt sky130_fd_sc_hd__clkinv_4 A VGND VNB VPB VPWR Y
.ends

* Black-box entry subcircuit for sky130_fd_sc_hd__o21a_1 abstract view
.subckt sky130_fd_sc_hd__o21a_1 A1 A2 B1 VGND VNB VPB VPWR X
.ends

* Black-box entry subcircuit for sky130_fd_sc_hd__clkinvlp_4 abstract view
.subckt sky130_fd_sc_hd__clkinvlp_4 A VGND VNB VPB VPWR Y
.ends

* Black-box entry subcircuit for sky130_fd_sc_hd__or3_4 abstract view
.subckt sky130_fd_sc_hd__or3_4 A B C VGND VNB VPB VPWR X
.ends

* Black-box entry subcircuit for sky130_fd_sc_hd__inv_6 abstract view
.subckt sky130_fd_sc_hd__inv_6 A VGND VNB VPB VPWR Y
.ends

* Black-box entry subcircuit for sky130_fd_sc_hd__dfrtp_2 abstract view
.subckt sky130_fd_sc_hd__dfrtp_2 CLK D RESET_B VGND VNB VPB VPWR Q
.ends

* Black-box entry subcircuit for sky130_fd_sc_hd__nor3_1 abstract view
.subckt sky130_fd_sc_hd__nor3_1 A B C VGND VNB VPB VPWR Y
.ends

* Black-box entry subcircuit for sky130_fd_sc_hd__dlymetal6s2s_1 abstract view
.subckt sky130_fd_sc_hd__dlymetal6s2s_1 A VGND VNB VPB VPWR X
.ends

* Black-box entry subcircuit for sky130_fd_sc_hd__and4b_1 abstract view
.subckt sky130_fd_sc_hd__and4b_1 A_N B C D VGND VNB VPB VPWR X
.ends

* Black-box entry subcircuit for sky130_fd_sc_hd__a22o_1 abstract view
.subckt sky130_fd_sc_hd__a22o_1 A1 A2 B1 B2 VGND VNB VPB VPWR X
.ends

* Black-box entry subcircuit for sky130_fd_sc_hd__nor3b_1 abstract view
.subckt sky130_fd_sc_hd__nor3b_1 A B C_N VGND VNB VPB VPWR Y
.ends

* Black-box entry subcircuit for sky130_fd_sc_hd__clkinv_2 abstract view
.subckt sky130_fd_sc_hd__clkinv_2 A VGND VNB VPB VPWR Y
.ends

* Black-box entry subcircuit for sky130_fd_sc_hd__clkbuf_1 abstract view
.subckt sky130_fd_sc_hd__clkbuf_1 A VGND VNB VPB VPWR X
.ends

* Black-box entry subcircuit for sky130_fd_sc_hd__a31oi_1 abstract view
.subckt sky130_fd_sc_hd__a31oi_1 A1 A2 A3 B1 VGND VNB VPB VPWR Y
.ends

* Black-box entry subcircuit for sky130_fd_sc_hd__nor4_1 abstract view
.subckt sky130_fd_sc_hd__nor4_1 A B C D VGND VNB VPB VPWR Y
.ends

* Black-box entry subcircuit for sky130_fd_sc_hd__xor2_1 abstract view
.subckt sky130_fd_sc_hd__xor2_1 A B VGND VNB VPB VPWR X
.ends

* Black-box entry subcircuit for sky130_fd_sc_hd__a2bb2o_1 abstract view
.subckt sky130_fd_sc_hd__a2bb2o_1 A1_N A2_N B1 B2 VGND VNB VPB VPWR X
.ends

* Black-box entry subcircuit for sky130_fd_sc_hd__conb_1 abstract view
.subckt sky130_fd_sc_hd__conb_1 VGND VNB VPB VPWR HI LO
.ends

* Black-box entry subcircuit for sky130_fd_sc_hd__buf_1 abstract view
.subckt sky130_fd_sc_hd__buf_1 A VGND VNB VPB VPWR X
.ends

* Black-box entry subcircuit for sky130_fd_sc_hd__and2b_1 abstract view
.subckt sky130_fd_sc_hd__and2b_1 A_N B VGND VNB VPB VPWR X
.ends

* Black-box entry subcircuit for sky130_fd_sc_hd__and4bb_1 abstract view
.subckt sky130_fd_sc_hd__and4bb_1 A_N B_N C D VGND VNB VPB VPWR X
.ends

* Black-box entry subcircuit for sky130_fd_sc_hd__o2111a_1 abstract view
.subckt sky130_fd_sc_hd__o2111a_1 A1 A2 B1 C1 D1 VGND VNB VPB VPWR X
.ends

* Black-box entry subcircuit for sky130_fd_sc_hd__nand2b_4 abstract view
.subckt sky130_fd_sc_hd__nand2b_4 A_N B VGND VNB VPB VPWR Y
.ends

* Black-box entry subcircuit for sky130_fd_sc_hd__or3b_1 abstract view
.subckt sky130_fd_sc_hd__or3b_1 A B C_N VGND VNB VPB VPWR X
.ends

* Black-box entry subcircuit for sky130_fd_sc_hd__xnor2_1 abstract view
.subckt sky130_fd_sc_hd__xnor2_1 A B VGND VNB VPB VPWR Y
.ends

* Black-box entry subcircuit for sky130_fd_sc_hd__dfstp_1 abstract view
.subckt sky130_fd_sc_hd__dfstp_1 CLK D SET_B VGND VNB VPB VPWR Q
.ends

* Black-box entry subcircuit for sky130_fd_sc_hd__a21bo_1 abstract view
.subckt sky130_fd_sc_hd__a21bo_1 A1 A2 B1_N VGND VNB VPB VPWR X
.ends

* Black-box entry subcircuit for sky130_fd_sc_hd__o32a_1 abstract view
.subckt sky130_fd_sc_hd__o32a_1 A1 A2 A3 B1 B2 VGND VNB VPB VPWR X
.ends

* Black-box entry subcircuit for sky130_fd_sc_hd__o221a_1 abstract view
.subckt sky130_fd_sc_hd__o221a_1 A1 A2 B1 B2 C1 VGND VNB VPB VPWR X
.ends

* Black-box entry subcircuit for sky130_fd_sc_hd__o21bai_1 abstract view
.subckt sky130_fd_sc_hd__o21bai_1 A1 A2 B1_N VGND VNB VPB VPWR Y
.ends

* Black-box entry subcircuit for sky130_fd_sc_hd__o2bb2a_1 abstract view
.subckt sky130_fd_sc_hd__o2bb2a_1 A1_N A2_N B1 B2 VGND VNB VPB VPWR X
.ends

* Black-box entry subcircuit for sky130_fd_sc_hd__and4_2 abstract view
.subckt sky130_fd_sc_hd__and4_2 A B C D VGND VNB VPB VPWR X
.ends

* Black-box entry subcircuit for sky130_fd_sc_hd__or3b_2 abstract view
.subckt sky130_fd_sc_hd__or3b_2 A B C_N VGND VNB VPB VPWR X
.ends

* Black-box entry subcircuit for sky130_fd_sc_hd__a32o_1 abstract view
.subckt sky130_fd_sc_hd__a32o_1 A1 A2 A3 B1 B2 VGND VNB VPB VPWR X
.ends

* Black-box entry subcircuit for sky130_fd_sc_hd__o221ai_1 abstract view
.subckt sky130_fd_sc_hd__o221ai_1 A1 A2 B1 B2 C1 VGND VNB VPB VPWR Y
.ends

* Black-box entry subcircuit for sky130_fd_sc_hd__a21boi_1 abstract view
.subckt sky130_fd_sc_hd__a21boi_1 A1 A2 B1_N VGND VNB VPB VPWR Y
.ends

* Black-box entry subcircuit for sky130_fd_sc_hd__or2_2 abstract view
.subckt sky130_fd_sc_hd__or2_2 A B VGND VNB VPB VPWR X
.ends

* Black-box entry subcircuit for sky130_fd_sc_hd__dfrtp_4 abstract view
.subckt sky130_fd_sc_hd__dfrtp_4 CLK D RESET_B VGND VNB VPB VPWR Q
.ends

* Black-box entry subcircuit for sky130_fd_sc_hd__and2b_2 abstract view
.subckt sky130_fd_sc_hd__and2b_2 A_N B VGND VNB VPB VPWR X
.ends

* Black-box entry subcircuit for sky130_fd_sc_hd__nor2_2 abstract view
.subckt sky130_fd_sc_hd__nor2_2 A B VGND VNB VPB VPWR Y
.ends

.subckt SSS AN[0] AN[1] AN[2] AN[3] AN[4] AN[5] AN[6] AN[7] BTNC BTND BTNL BTNR BTNU
+ CA CB CC CD CE CF CG CLK CPU_RESETN DP LED16_B LED16_G LED16_R LED[0] LED[10] LED[11]
+ LED[12] LED[13] LED[14] LED[15] LED[1] LED[2] LED[3] LED[4] LED[5] LED[6] LED[7]
+ LED[8] LED[9] SW[0] SW[10] SW[11] SW[12] SW[13] SW[14] SW[15] SW[1] SW[2] SW[3]
+ SW[4] SW[5] SW[6] SW[7] SW[8] SW[9] VGND VPWR
XTAP_TAPCELL_ROW_32_194 VGND VPWR sky130_fd_sc_hd__tapvpwrvgnd_1
XPHY_EDGE_ROW_37_Left_75 VGND VGND VPWR VPWR sky130_fd_sc_hd__decap_3
XFILLER_26_85 VGND VGND VPWR VPWR sky130_fd_sc_hd__decap_3
XTAP_TAPCELL_ROW_23_161 VGND VPWR sky130_fd_sc_hd__tapvpwrvgnd_1
X_501_ CLK_counter\[17\] CLK_counter\[16\] VGND VGND VPWR VPWR _204_ sky130_fd_sc_hd__and2_1
XPHY_EDGE_ROW_21_Left_59 VGND VGND VPWR VPWR sky130_fd_sc_hd__decap_3
XFILLER_13_144 VGND VGND VPWR VPWR sky130_fd_sc_hd__decap_8
XFILLER_13_122 VPWR VGND VPWR VGND sky130_ef_sc_hd__decap_12
X_432_ _109_ _152_ VGND VGND VPWR VPWR _153_ sky130_fd_sc_hd__nand2_2
X_363_ net60 net59 VGND VGND VPWR VPWR _089_ sky130_fd_sc_hd__nand2b_1
XFILLER_9_159 VGND VGND VPWR VPWR sky130_fd_sc_hd__fill_1
XFILLER_9_137 VGND VGND VPWR VPWR sky130_fd_sc_hd__decap_6
XFILLER_27_203 VPWR VGND VPWR VGND sky130_ef_sc_hd__decap_12
XFILLER_8_170 VPWR VGND VPWR VGND sky130_ef_sc_hd__decap_12
XFILLER_33_217 VGND VGND VPWR VPWR sky130_fd_sc_hd__decap_4
X_415_ CLK2_counter\[5\] CLK2_counter\[12\] CLK2_counter\[11\] CLK2_counter\[13\]
+ VGND VGND VPWR VPWR _137_ sky130_fd_sc_hd__or4b_1
XFILLER_6_129 VGND VGND VPWR VPWR sky130_fd_sc_hd__decap_3
XTAP_TAPCELL_ROW_34_201 VGND VPWR sky130_fd_sc_hd__tapvpwrvgnd_1
XFILLER_24_217 VGND VGND VPWR VPWR sky130_fd_sc_hd__fill_1
XTAP_TAPCELL_ROW_11_120 VGND VPWR sky130_fd_sc_hd__tapvpwrvgnd_1
XFILLER_5_162 VGND VGND VPWR VPWR sky130_fd_sc_hd__decap_6
XFILLER_30_209 VGND VGND VPWR VPWR sky130_fd_sc_hd__decap_8
XPHY_EDGE_ROW_24_Left_62 VGND VGND VPWR VPWR sky130_fd_sc_hd__decap_3
XFILLER_0_57 VPWR VGND VPWR VGND sky130_ef_sc_hd__decap_12
XFILLER_34_85 VPWR VGND VPWR VGND sky130_ef_sc_hd__decap_12
XFILLER_34_41 VPWR VGND VPWR VGND sky130_ef_sc_hd__decap_12
X_680_ CLK2_counter\[20\] _312_ _316_ CLK2_counter\[21\] VGND VGND VPWR VPWR _319_
+ sky130_fd_sc_hd__a31o_1
XFILLER_18_42 VPWR VGND VPWR VGND sky130_ef_sc_hd__decap_12
X_801_ clknet_3_6__leaf_CLK _021_ net69 VGND VGND VPWR VPWR CLK_counter\[29\] sky130_fd_sc_hd__dfrtp_1
X_663_ _307_ net52 _306_ VGND VGND VPWR VPWR _047_ sky130_fd_sc_hd__and3b_1
XFILLER_20_65 VGND VGND VPWR VPWR sky130_fd_sc_hd__decap_6
X_594_ _153_ _269_ _155_ VGND VGND VPWR VPWR _270_ sky130_fd_sc_hd__o21ai_1
X_732_ net11 net81 _349_ VGND VGND VPWR VPWR _074_ sky130_fd_sc_hd__mux2_1
XFILLER_34_197 VPWR VGND VPWR VGND sky130_ef_sc_hd__decap_12
XFILLER_34_153 VPWR VGND VPWR VGND sky130_ef_sc_hd__decap_12
XFILLER_25_186 VPWR VGND VPWR VGND sky130_ef_sc_hd__decap_12
XFILLER_31_167 VGND VGND VPWR VPWR sky130_fd_sc_hd__fill_1
Xoutput31 net31 VGND VGND VPWR VPWR LED[0] sky130_fd_sc_hd__buf_2
XTAP_TAPCELL_ROW_26_170 VGND VPWR sky130_fd_sc_hd__tapvpwrvgnd_1
X_646_ CLK2_counter\[7\] CLK2_counter\[10\] _099_ _289_ VGND VGND VPWR VPWR _296_
+ sky130_fd_sc_hd__and4_1
XFILLER_16_120 VGND VGND VPWR VPWR sky130_fd_sc_hd__decap_3
Xoutput42 net42 VGND VGND VPWR VPWR LED[5] sky130_fd_sc_hd__buf_2
X_715_ attempt_count\[0\] net1 net57 VGND VGND VPWR VPWR _343_ sky130_fd_sc_hd__and3_1
X_577_ _080_ CLK2_counter\[8\] _134_ _153_ VGND VGND VPWR VPWR _257_ sky130_fd_sc_hd__or4_1
Xoutput20 net20 VGND VGND VPWR VPWR AN[6] sky130_fd_sc_hd__buf_2
XFILLER_22_112 VGND VGND VPWR VPWR sky130_fd_sc_hd__fill_1
XTAP_TAPCELL_ROW_23_162 VGND VPWR sky130_fd_sc_hd__tapvpwrvgnd_1
X_500_ CLK_counter\[16\] _201_ CLK_counter\[17\] VGND VGND VPWR VPWR _203_ sky130_fd_sc_hd__a21oi_1
XFILLER_13_134 VGND VGND VPWR VPWR sky130_fd_sc_hd__decap_4
X_431_ _149_ _151_ _098_ VGND VGND VPWR VPWR _152_ sky130_fd_sc_hd__a21oi_1
X_362_ net59 net58 VGND VGND VPWR VPWR _088_ sky130_fd_sc_hd__nand2_1
XFILLER_27_215 VGND VGND VPWR VPWR sky130_fd_sc_hd__fill_2
X_629_ CLK2_counter\[4\] _283_ VGND VGND VPWR VPWR _285_ sky130_fd_sc_hd__and2_1
XFILLER_8_182 VPWR VGND VPWR VGND sky130_ef_sc_hd__decap_12
XFILLER_37_85 VPWR VGND VPWR VGND sky130_ef_sc_hd__decap_12
XTAP_TAPCELL_ROW_37_210 VGND VPWR sky130_fd_sc_hd__tapvpwrvgnd_1
XFILLER_37_41 VPWR VGND VPWR VGND sky130_ef_sc_hd__decap_12
XFILLER_12_66 VGND VGND VPWR VPWR sky130_fd_sc_hd__decap_4
XFILLER_12_11 VGND VGND VPWR VPWR sky130_fd_sc_hd__fill_1
X_414_ CLK2_counter\[3\] CLK2_counter\[6\] CLK2_counter\[7\] CLK2_counter\[4\] VGND
+ VGND VPWR VPWR _136_ sky130_fd_sc_hd__or4b_1
XPHY_EDGE_ROW_21_Right_21 VGND VGND VPWR VPWR sky130_fd_sc_hd__decap_3
XPHY_EDGE_ROW_12_Right_12 VGND VGND VPWR VPWR sky130_fd_sc_hd__decap_3
XPHY_EDGE_ROW_30_Right_30 VGND VGND VPWR VPWR sky130_fd_sc_hd__decap_3
XFILLER_0_69 VGND VGND VPWR VPWR sky130_fd_sc_hd__decap_4
XFILLER_34_97 VPWR VGND VPWR VGND sky130_ef_sc_hd__decap_12
XFILLER_34_53 VPWR VGND VPWR VGND sky130_ef_sc_hd__decap_12
XFILLER_18_54 VGND VGND VPWR VPWR sky130_fd_sc_hd__decap_8
XFILLER_15_7 VGND VGND VPWR VPWR sky130_fd_sc_hd__decap_4
X_800_ clknet_3_3__leaf_CLK _020_ net70 VGND VGND VPWR VPWR CLK_counter\[28\] sky130_fd_sc_hd__dfrtp_1
X_662_ CLK2_counter\[15\] CLK2_counter\[14\] _303_ VGND VGND VPWR VPWR _307_ sky130_fd_sc_hd__and3_1
XFILLER_20_44 VGND VGND VPWR VPWR sky130_fd_sc_hd__fill_1
Xhold20 CLK_counter\[10\] VGND VGND VPWR VPWR net97 sky130_fd_sc_hd__dlygate4sd3_1
X_731_ net10 password\[4\] _349_ VGND VGND VPWR VPWR _073_ sky130_fd_sc_hd__mux2_1
XFILLER_34_121 VPWR VGND VPWR VGND sky130_ef_sc_hd__decap_12
X_593_ CLK2_counter\[10\] CLK2_counter\[9\] VGND VGND VPWR VPWR _269_ sky130_fd_sc_hd__nor2_1
XFILLER_34_165 VPWR VGND VPWR VGND sky130_ef_sc_hd__decap_12
XFILLER_25_198 VPWR VGND VPWR VGND sky130_ef_sc_hd__decap_12
XFILLER_25_132 VGND VGND VPWR VPWR sky130_fd_sc_hd__fill_1
XFILLER_25_121 VGND VGND VPWR VPWR sky130_fd_sc_hd__decap_3
XFILLER_15_22 VGND VGND VPWR VPWR sky130_fd_sc_hd__fill_2
XPHY_EDGE_ROW_6_Right_6 VGND VGND VPWR VPWR sky130_fd_sc_hd__decap_3
X_714_ net51 _341_ _342_ VGND VGND VPWR VPWR _063_ sky130_fd_sc_hd__and3_1
XFILLER_31_21 VGND VGND VPWR VPWR sky130_fd_sc_hd__fill_1
XTAP_TAPCELL_ROW_26_171 VGND VPWR sky130_fd_sc_hd__tapvpwrvgnd_1
Xoutput32 net32 VGND VGND VPWR VPWR LED[10] sky130_fd_sc_hd__buf_2
Xoutput43 net43 VGND VGND VPWR VPWR LED[6] sky130_fd_sc_hd__buf_2
X_645_ _295_ net47 _294_ VGND VGND VPWR VPWR _041_ sky130_fd_sc_hd__and3b_1
Xoutput21 net21 VGND VGND VPWR VPWR AN[7] sky130_fd_sc_hd__buf_2
X_576_ _243_ _246_ _248_ VGND VGND VPWR VPWR _256_ sky130_fd_sc_hd__and3_1
XFILLER_22_157 VGND VGND VPWR VPWR sky130_fd_sc_hd__fill_1
X_430_ _101_ _103_ _150_ VGND VGND VPWR VPWR _151_ sky130_fd_sc_hd__or3_1
XFILLER_13_113 VGND VGND VPWR VPWR sky130_fd_sc_hd__decap_4
X_361_ net13 VGND VGND VPWR VPWR _087_ sky130_fd_sc_hd__inv_2
X_628_ CLK2_counter\[4\] _283_ VGND VGND VPWR VPWR _284_ sky130_fd_sc_hd__or2_1
XTAP_TAPCELL_ROW_14_130 VGND VPWR sky130_fd_sc_hd__tapvpwrvgnd_1
X_559_ _078_ _123_ _241_ net15 VGND VGND VPWR VPWR net16 sky130_fd_sc_hd__o31a_1
XFILLER_3_36 VGND VGND VPWR VPWR sky130_fd_sc_hd__fill_1
XTAP_TAPCELL_ROW_3_90 VGND VPWR sky130_fd_sc_hd__tapvpwrvgnd_1
XFILLER_8_194 VGND VGND VPWR VPWR sky130_fd_sc_hd__fill_2
XTAP_TAPCELL_ROW_37_211 VGND VPWR sky130_fd_sc_hd__tapvpwrvgnd_1
XFILLER_37_97 VPWR VGND VPWR VGND sky130_ef_sc_hd__decap_12
XFILLER_37_53 VGND VGND VPWR VPWR sky130_fd_sc_hd__decap_3
XFILLER_18_205 VGND VGND VPWR VPWR sky130_fd_sc_hd__fill_2
X_413_ _100_ _134_ VGND VGND VPWR VPWR _135_ sky130_fd_sc_hd__or2_1
XFILLER_23_55 VGND VGND VPWR VPWR sky130_fd_sc_hd__fill_1
XFILLER_0_15 VPWR VGND VPWR VGND sky130_ef_sc_hd__decap_12
XFILLER_2_123 VGND VGND VPWR VPWR sky130_fd_sc_hd__fill_2
XFILLER_3_3 VGND VGND VPWR VPWR sky130_fd_sc_hd__decap_8
XFILLER_9_35 VGND VGND VPWR VPWR sky130_fd_sc_hd__fill_1
XFILLER_36_3 VPWR VGND VPWR VGND sky130_ef_sc_hd__decap_12
XTAP_TAPCELL_ROW_0_80 VGND VPWR sky130_fd_sc_hd__tapvpwrvgnd_1
XFILLER_9_57 VGND VGND VPWR VPWR sky130_fd_sc_hd__decap_8
XFILLER_34_65 VPWR VGND VPWR VGND sky130_ef_sc_hd__decap_12
XFILLER_18_88 VPWR VGND VPWR VGND sky130_ef_sc_hd__decap_12
XFILLER_37_141 VPWR VGND VPWR VGND sky130_ef_sc_hd__decap_12
XFILLER_28_141 VGND VGND VPWR VPWR sky130_fd_sc_hd__decap_6
Xhold10 CLK2_counter\[29\] VGND VGND VPWR VPWR net87 sky130_fd_sc_hd__dlygate4sd3_1
X_661_ CLK2_counter\[14\] _303_ CLK2_counter\[15\] VGND VGND VPWR VPWR _306_ sky130_fd_sc_hd__a21o_1
Xhold21 attempt_count\[0\] VGND VGND VPWR VPWR net98 sky130_fd_sc_hd__dlygate4sd3_1
X_730_ net9 password\[3\] _349_ VGND VGND VPWR VPWR _072_ sky130_fd_sc_hd__mux2_1
X_592_ _263_ _266_ _268_ VGND VGND VPWR VPWR net23 sky130_fd_sc_hd__and3_1
XFILLER_34_177 VPWR VGND VPWR VGND sky130_ef_sc_hd__decap_12
XFILLER_34_133 VGND VGND VPWR VPWR sky130_fd_sc_hd__decap_6
Xoutput44 net44 VGND VGND VPWR VPWR LED[7] sky130_fd_sc_hd__buf_2
X_713_ CLK2_counter\[31\] CLK2_counter\[30\] _334_ _337_ VGND VGND VPWR VPWR _342_
+ sky130_fd_sc_hd__nand4_1
Xoutput33 net33 VGND VGND VPWR VPWR LED[11] sky130_fd_sc_hd__buf_2
Xoutput22 net22 VGND VGND VPWR VPWR CA sky130_fd_sc_hd__buf_2
X_644_ CLK2_counter\[7\] _099_ _289_ VGND VGND VPWR VPWR _295_ sky130_fd_sc_hd__and3_1
X_575_ _135_ _153_ _252_ _255_ VGND VGND VPWR VPWR net27 sky130_fd_sc_hd__o211a_1
XTAP_TAPCELL_ROW_26_172 VGND VPWR sky130_fd_sc_hd__tapvpwrvgnd_1
XFILLER_26_77 VGND VGND VPWR VPWR sky130_fd_sc_hd__decap_6
X_360_ net12 VGND VGND VPWR VPWR _086_ sky130_fd_sc_hd__inv_2
X_489_ CLK_counter\[13\] CLK_counter\[12\] _192_ VGND VGND VPWR VPWR _196_ sky130_fd_sc_hd__and3_1
XTAP_TAPCELL_ROW_14_131 VGND VPWR sky130_fd_sc_hd__tapvpwrvgnd_1
X_627_ _282_ _283_ VGND VGND VPWR VPWR _035_ sky130_fd_sc_hd__nor2_1
Xclkbuf_3_4__f_CLK clknet_0_CLK VGND VGND VPWR VPWR clknet_3_4__leaf_CLK sky130_fd_sc_hd__clkbuf_16
X_558_ net64 _079_ VGND VGND VPWR VPWR _241_ sky130_fd_sc_hd__or2_1
XTAP_TAPCELL_ROW_37_212 VGND VPWR sky130_fd_sc_hd__tapvpwrvgnd_1
XTAP_TAPCELL_ROW_3_91 VGND VPWR sky130_fd_sc_hd__tapvpwrvgnd_1
X_412_ CLK2_counter\[10\] _133_ VGND VGND VPWR VPWR _134_ sky130_fd_sc_hd__nand2_1
XFILLER_5_121 VGND VGND VPWR VPWR sky130_fd_sc_hd__decap_8
XFILLER_5_198 VGND VGND VPWR VPWR sky130_fd_sc_hd__fill_2
XFILLER_24_209 VGND VGND VPWR VPWR sky130_fd_sc_hd__decap_8
XFILLER_0_27 VGND VGND VPWR VPWR sky130_fd_sc_hd__fill_1
XFILLER_2_135 VGND VGND VPWR VPWR sky130_fd_sc_hd__decap_4
XFILLER_29_3 VPWR VGND VPWR VGND sky130_ef_sc_hd__decap_12
XTAP_TAPCELL_ROW_0_81 VGND VPWR sky130_fd_sc_hd__tapvpwrvgnd_1
XFILLER_34_77 VGND VGND VPWR VPWR sky130_fd_sc_hd__decap_6
XPHY_EDGE_ROW_28_Left_66 VGND VGND VPWR VPWR sky130_fd_sc_hd__decap_3
XFILLER_37_197 VPWR VGND VPWR VGND sky130_ef_sc_hd__decap_12
XFILLER_37_153 VPWR VGND VPWR VGND sky130_ef_sc_hd__decap_12
XFILLER_28_197 VPWR VGND VPWR VGND sky130_ef_sc_hd__decap_12
X_660_ _304_ _305_ net52 VGND VGND VPWR VPWR _046_ sky130_fd_sc_hd__and3b_1
Xhold11 CLK_counter\[11\] VGND VGND VPWR VPWR net88 sky130_fd_sc_hd__dlygate4sd3_1
X_591_ net64 _242_ _267_ net62 VGND VGND VPWR VPWR _268_ sky130_fd_sc_hd__o22a_1
XFILLER_34_189 VGND VGND VPWR VPWR sky130_fd_sc_hd__decap_6
XTAP_TAPCELL_ROW_29_181 VGND VPWR sky130_fd_sc_hd__tapvpwrvgnd_1
X_789_ clknet_3_2__leaf_CLK _008_ net68 VGND VGND VPWR VPWR CLK_counter\[17\] sky130_fd_sc_hd__dfrtp_1
X_712_ CLK2_counter\[30\] _334_ _337_ CLK2_counter\[31\] VGND VGND VPWR VPWR _341_
+ sky130_fd_sc_hd__a31o_1
Xoutput34 net34 VGND VGND VPWR VPWR LED[12] sky130_fd_sc_hd__buf_2
Xoutput23 net23 VGND VGND VPWR VPWR CB sky130_fd_sc_hd__buf_2
Xoutput45 net45 VGND VGND VPWR VPWR LED[8] sky130_fd_sc_hd__buf_2
XTAP_TAPCELL_ROW_26_173 VGND VPWR sky130_fd_sc_hd__tapvpwrvgnd_1
X_643_ _080_ _293_ VGND VGND VPWR VPWR _294_ sky130_fd_sc_hd__nand2_1
XFILLER_11_3 VGND VGND VPWR VPWR sky130_fd_sc_hd__fill_2
X_574_ _244_ _253_ _254_ VGND VGND VPWR VPWR _255_ sky130_fd_sc_hd__and3_1
XTAP_TAPCELL_ROW_17_140 VGND VPWR sky130_fd_sc_hd__tapvpwrvgnd_1
XPHY_EDGE_ROW_15_Left_53 VGND VGND VPWR VPWR sky130_fd_sc_hd__decap_3
XFILLER_13_104 VGND VGND VPWR VPWR sky130_fd_sc_hd__fill_1
X_488_ _194_ _195_ VGND VGND VPWR VPWR _003_ sky130_fd_sc_hd__nor2_1
X_626_ CLK2_counter\[3\] net56 _169_ _279_ VGND VGND VPWR VPWR _283_ sky130_fd_sc_hd__and4_1
X_557_ net58 _233_ _240_ VGND VGND VPWR VPWR net17 sky130_fd_sc_hd__or3_1
XTAP_TAPCELL_ROW_37_213 VGND VPWR sky130_fd_sc_hd__tapvpwrvgnd_1
XFILLER_12_170 VGND VGND VPWR VPWR sky130_fd_sc_hd__decap_8
XTAP_TAPCELL_ROW_3_92 VGND VPWR sky130_fd_sc_hd__tapvpwrvgnd_1
X_411_ net58 _089_ VGND VGND VPWR VPWR _133_ sky130_fd_sc_hd__nor2_1
XPHY_EDGE_ROW_0_Left_38 VGND VGND VPWR VPWR sky130_fd_sc_hd__decap_3
X_609_ attempt_count\[4\] attempt_count\[0\] attempt_count\[1\] attempt_count\[2\]
+ VGND VGND VPWR VPWR _277_ sky130_fd_sc_hd__or4_1
XTAP_TAPCELL_ROW_0_82 VGND VPWR sky130_fd_sc_hd__tapvpwrvgnd_1
XFILLER_9_15 VPWR VGND VPWR VGND sky130_ef_sc_hd__decap_12
XFILLER_18_24 VGND VGND VPWR VPWR sky130_fd_sc_hd__decap_4
Xclkload0 clknet_3_0__leaf_CLK VGND VGND VPWR VPWR clkload0/X sky130_fd_sc_hd__clkbuf_4
XPHY_EDGE_ROW_3_Left_41 VGND VGND VPWR VPWR sky130_fd_sc_hd__decap_3
XFILLER_37_165 VGND VGND VPWR VPWR sky130_fd_sc_hd__decap_3
XFILLER_28_154 VPWR VGND VPWR VGND sky130_ef_sc_hd__decap_12
X_590_ _122_ _249_ _250_ _092_ VGND VGND VPWR VPWR _267_ sky130_fd_sc_hd__a22oi_1
Xhold12 CLK_counter\[7\] VGND VGND VPWR VPWR net89 sky130_fd_sc_hd__dlygate4sd3_1
XTAP_TAPCELL_ROW_29_182 VGND VPWR sky130_fd_sc_hd__tapvpwrvgnd_1
X_788_ clknet_3_2__leaf_CLK _007_ net68 VGND VGND VPWR VPWR CLK_counter\[16\] sky130_fd_sc_hd__dfrtp_1
XFILLER_31_68 VPWR VGND VPWR VGND sky130_ef_sc_hd__decap_12
XFILLER_31_57 VGND VGND VPWR VPWR sky130_fd_sc_hd__fill_2
XFILLER_25_113 VGND VGND VPWR VPWR sky130_fd_sc_hd__decap_8
Xoutput35 net35 VGND VGND VPWR VPWR LED[13] sky130_fd_sc_hd__buf_2
Xoutput24 net24 VGND VGND VPWR VPWR CC sky130_fd_sc_hd__buf_2
Xoutput46 net46 VGND VGND VPWR VPWR LED[9] sky130_fd_sc_hd__buf_2
X_711_ _340_ net49 _339_ VGND VGND VPWR VPWR _062_ sky130_fd_sc_hd__and3b_1
XPHY_EDGE_ROW_28_Right_28 VGND VGND VPWR VPWR sky130_fd_sc_hd__decap_3
XPHY_EDGE_ROW_19_Right_19 VGND VGND VPWR VPWR sky130_fd_sc_hd__decap_3
XFILLER_16_146 VGND VGND VPWR VPWR sky130_fd_sc_hd__fill_2
X_642_ net48 _292_ _293_ VGND VGND VPWR VPWR _040_ sky130_fd_sc_hd__and3_1
X_573_ net62 _241_ _123_ VGND VGND VPWR VPWR _254_ sky130_fd_sc_hd__a21o_1
XPHY_EDGE_ROW_37_Right_37 VGND VGND VPWR VPWR sky130_fd_sc_hd__decap_3
XFILLER_22_149 VGND VGND VPWR VPWR sky130_fd_sc_hd__decap_8
XTAP_TAPCELL_ROW_17_141 VGND VPWR sky130_fd_sc_hd__tapvpwrvgnd_1
XFILLER_13_138 VGND VGND VPWR VPWR sky130_fd_sc_hd__fill_1
X_625_ CLK2_counter\[3\] _280_ net48 VGND VGND VPWR VPWR _282_ sky130_fd_sc_hd__o21ai_1
XTAP_TAPCELL_ROW_37_214 VGND VPWR sky130_fd_sc_hd__tapvpwrvgnd_1
XPHY_EDGE_ROW_32_Left_70 VGND VGND VPWR VPWR sky130_fd_sc_hd__decap_3
X_487_ CLK_counter\[12\] _192_ net47 VGND VGND VPWR VPWR _195_ sky130_fd_sc_hd__o21ai_1
XFILLER_12_182 VPWR VGND VPWR VGND sky130_ef_sc_hd__decap_12
X_556_ net62 _106_ net59 VGND VGND VPWR VPWR _240_ sky130_fd_sc_hd__a21oi_1
XFILLER_12_26 VGND VGND VPWR VPWR sky130_fd_sc_hd__fill_2
X_410_ _111_ _132_ _088_ _089_ VGND VGND VPWR VPWR next_state\[1\] sky130_fd_sc_hd__or4bb_1
X_539_ net91 _227_ net50 VGND VGND VPWR VPWR _229_ sky130_fd_sc_hd__o21ai_1
X_608_ attempt_count\[4\] attempt_count\[1\] net61 _273_ VGND VGND VPWR VPWR net43
+ sky130_fd_sc_hd__o31ai_1
XFILLER_23_211 VGND VGND VPWR VPWR sky130_fd_sc_hd__decap_8
XFILLER_4_71 VPWR VGND VPWR VGND sky130_ef_sc_hd__decap_12
Xfanout70 net75 VGND VGND VPWR VPWR net70 sky130_fd_sc_hd__clkbuf_2
XFILLER_14_200 VGND VGND VPWR VPWR sky130_fd_sc_hd__decap_8
XFILLER_0_29 VPWR VGND VPWR VGND sky130_ef_sc_hd__decap_12
XFILLER_9_27 VGND VGND VPWR VPWR sky130_fd_sc_hd__decap_4
Xclkload1 clknet_3_1__leaf_CLK VGND VGND VPWR VPWR clkload1/Y sky130_fd_sc_hd__clkinv_4
XFILLER_1_3 VGND VGND VPWR VPWR sky130_fd_sc_hd__decap_6
XFILLER_34_3 VPWR VGND VPWR VGND sky130_ef_sc_hd__decap_12
XFILLER_29_57 VGND VGND VPWR VPWR sky130_fd_sc_hd__fill_2
XFILLER_28_166 VGND VGND VPWR VPWR sky130_fd_sc_hd__decap_3
Xhold13 password\[1\] VGND VGND VPWR VPWR net90 sky130_fd_sc_hd__dlygate4sd3_1
XTAP_TAPCELL_ROW_29_183 VGND VPWR sky130_fd_sc_hd__tapvpwrvgnd_1
XFILLER_19_177 VGND VGND VPWR VPWR sky130_fd_sc_hd__fill_2
X_787_ clknet_3_0__leaf_CLK _006_ net66 VGND VGND VPWR VPWR CLK_counter\[15\] sky130_fd_sc_hd__dfrtp_1
XFILLER_6_39 VGND VGND VPWR VPWR sky130_fd_sc_hd__decap_4
X_710_ CLK2_counter\[30\] _334_ _337_ VGND VGND VPWR VPWR _340_ sky130_fd_sc_hd__and3_1
Xoutput14 net14 VGND VGND VPWR VPWR AN[0] sky130_fd_sc_hd__buf_2
Xoutput36 net36 VGND VGND VPWR VPWR LED[14] sky130_fd_sc_hd__buf_2
X_641_ CLK2_counter\[8\] _291_ VGND VGND VPWR VPWR _293_ sky130_fd_sc_hd__nand2_1
Xoutput25 net25 VGND VGND VPWR VPWR CD sky130_fd_sc_hd__buf_2
X_572_ net63 net64 _093_ VGND VGND VPWR VPWR _253_ sky130_fd_sc_hd__or3_1
XFILLER_30_194 VGND VGND VPWR VPWR sky130_fd_sc_hd__fill_2
XFILLER_22_139 VGND VGND VPWR VPWR sky130_fd_sc_hd__fill_1
XFILLER_22_106 VGND VGND VPWR VPWR sky130_fd_sc_hd__decap_6
XFILLER_7_93 VGND VGND VPWR VPWR sky130_fd_sc_hd__fill_2
XFILLER_26_58 VGND VGND VPWR VPWR sky130_fd_sc_hd__fill_1
XTAP_TAPCELL_ROW_8_110 VGND VPWR sky130_fd_sc_hd__tapvpwrvgnd_1
XFILLER_36_209 VPWR VGND VPWR VGND sky130_ef_sc_hd__decap_12
X_486_ CLK_counter\[12\] _192_ VGND VGND VPWR VPWR _194_ sky130_fd_sc_hd__and2_1
XFILLER_12_194 VGND VGND VPWR VPWR sky130_fd_sc_hd__fill_2
X_624_ _280_ _281_ net48 VGND VGND VPWR VPWR _034_ sky130_fd_sc_hd__and3b_1
X_555_ _233_ _239_ VGND VGND VPWR VPWR net18 sky130_fd_sc_hd__or2_1
XTAP_TAPCELL_ROW_37_215 VGND VPWR sky130_fd_sc_hd__tapvpwrvgnd_1
XFILLER_37_57 VPWR VGND VPWR VGND sky130_ef_sc_hd__decap_12
X_538_ CLK_counter\[29\] CLK_counter\[30\] _225_ VGND VGND VPWR VPWR _228_ sky130_fd_sc_hd__and3_1
X_607_ net45 _274_ net41 VGND VGND VPWR VPWR net42 sky130_fd_sc_hd__o21a_1
XFILLER_5_113 VGND VGND VPWR VPWR sky130_fd_sc_hd__fill_1
XFILLER_5_135 VGND VGND VPWR VPWR sky130_fd_sc_hd__decap_6
XFILLER_23_37 VPWR VGND VPWR VGND sky130_ef_sc_hd__decap_12
XFILLER_23_15 VPWR VGND VPWR VGND sky130_ef_sc_hd__decap_12
XFILLER_4_83 VGND VGND VPWR VPWR sky130_fd_sc_hd__fill_1
X_469_ _181_ _182_ _171_ VGND VGND VPWR VPWR _028_ sky130_fd_sc_hd__and3b_1
Xfanout71 net72 VGND VGND VPWR VPWR net71 sky130_fd_sc_hd__clkbuf_4
Xfanout60 state\[0\] VGND VGND VPWR VPWR net60 sky130_fd_sc_hd__clkbuf_2
Xclkload2 clknet_3_3__leaf_CLK VGND VGND VPWR VPWR clkload2/Y sky130_fd_sc_hd__clkinvlp_4
XFILLER_18_37 VGND VGND VPWR VPWR sky130_fd_sc_hd__fill_1
XFILLER_27_3 VGND VGND VPWR VPWR sky130_fd_sc_hd__decap_3
XFILLER_24_80 VGND VGND VPWR VPWR sky130_fd_sc_hd__decap_4
Xhold14 CLK_counter\[30\] VGND VGND VPWR VPWR net91 sky130_fd_sc_hd__dlygate4sd3_1
XFILLER_1_95 VGND VGND VPWR VPWR sky130_fd_sc_hd__fill_2
XFILLER_19_145 VGND VGND VPWR VPWR sky130_fd_sc_hd__decap_3
X_786_ clknet_3_3__leaf_CLK _005_ net66 VGND VGND VPWR VPWR CLK_counter\[14\] sky130_fd_sc_hd__dfrtp_1
XFILLER_33_181 VPWR VGND VPWR VGND sky130_ef_sc_hd__decap_12
Xoutput15 net15 VGND VGND VPWR VPWR AN[1] sky130_fd_sc_hd__buf_2
XFILLER_31_15 VGND VGND VPWR VPWR sky130_fd_sc_hd__decap_6
Xoutput37 net37 VGND VGND VPWR VPWR LED[15] sky130_fd_sc_hd__buf_2
XFILLER_16_137 VGND VGND VPWR VPWR sky130_fd_sc_hd__decap_3
X_640_ CLK2_counter\[8\] _291_ VGND VGND VPWR VPWR _292_ sky130_fd_sc_hd__or2_1
XPHY_EDGE_ROW_1_Right_1 VGND VGND VPWR VPWR sky130_fd_sc_hd__decap_3
Xoutput26 net26 VGND VGND VPWR VPWR CE sky130_fd_sc_hd__buf_2
X_571_ _237_ _242_ _251_ VGND VGND VPWR VPWR _252_ sky130_fd_sc_hd__o21a_1
X_769_ clknet_3_5__leaf_CLK _066_ net71 VGND VGND VPWR VPWR attempt_count\[2\] sky130_fd_sc_hd__dfrtp_1
XFILLER_7_61 VGND VGND VPWR VPWR sky130_fd_sc_hd__fill_1
XTAP_TAPCELL_ROW_31_190 VGND VPWR sky130_fd_sc_hd__tapvpwrvgnd_1
XFILLER_21_151 VPWR VGND VPWR VGND sky130_ef_sc_hd__decap_12
X_485_ _192_ _193_ VGND VGND VPWR VPWR _002_ sky130_fd_sc_hd__nor2_1
X_623_ net55 _169_ _237_ net63 VGND VGND VPWR VPWR _281_ sky130_fd_sc_hd__a31o_1
X_554_ net62 _092_ _238_ _231_ VGND VGND VPWR VPWR _239_ sky130_fd_sc_hd__o31a_1
XFILLER_8_122 VGND VGND VPWR VPWR sky130_fd_sc_hd__fill_1
XTAP_TAPCELL_ROW_20_149 VGND VPWR sky130_fd_sc_hd__tapvpwrvgnd_1
XPHY_EDGE_ROW_19_Left_57 VGND VGND VPWR VPWR sky130_fd_sc_hd__decap_3
XFILLER_37_69 VPWR VGND VPWR VGND sky130_ef_sc_hd__decap_12
XFILLER_5_158 VGND VGND VPWR VPWR sky130_fd_sc_hd__fill_1
XFILLER_5_169 VGND VGND VPWR VPWR sky130_fd_sc_hd__decap_6
XFILLER_27_91 VGND VGND VPWR VPWR sky130_fd_sc_hd__fill_1
X_537_ _227_ net53 _226_ VGND VGND VPWR VPWR _021_ sky130_fd_sc_hd__and3b_1
X_606_ net45 _276_ net39 VGND VGND VPWR VPWR net40 sky130_fd_sc_hd__o21a_1
X_399_ net60 net59 net58 VGND VGND VPWR VPWR _123_ sky130_fd_sc_hd__or3_4
X_468_ CLK_counter\[6\] _179_ VGND VGND VPWR VPWR _182_ sky130_fd_sc_hd__or2_1
XFILLER_23_49 VGND VGND VPWR VPWR sky130_fd_sc_hd__decap_6
XFILLER_23_27 VGND VGND VPWR VPWR sky130_fd_sc_hd__decap_4
XFILLER_2_139 VGND VGND VPWR VPWR sky130_fd_sc_hd__fill_1
Xfanout50 net53 VGND VGND VPWR VPWR net50 sky130_fd_sc_hd__clkbuf_2
Xfanout61 attempt_count\[2\] VGND VGND VPWR VPWR net61 sky130_fd_sc_hd__buf_2
Xfanout72 net75 VGND VGND VPWR VPWR net72 sky130_fd_sc_hd__clkbuf_2
XFILLER_13_71 VGND VGND VPWR VPWR sky130_fd_sc_hd__fill_1
XFILLER_34_15 VPWR VGND VPWR VGND sky130_ef_sc_hd__decap_12
Xclkload3 clknet_3_4__leaf_CLK VGND VGND VPWR VPWR clkload3/Y sky130_fd_sc_hd__inv_6
XFILLER_37_113 VPWR VGND VPWR VGND sky130_ef_sc_hd__decap_12
XFILLER_29_15 VGND VGND VPWR VPWR sky130_fd_sc_hd__decap_6
XFILLER_29_48 VGND VGND VPWR VPWR sky130_fd_sc_hd__fill_2
Xhold15 CLK_counter\[19\] VGND VGND VPWR VPWR net92 sky130_fd_sc_hd__dlygate4sd3_1
XFILLER_19_113 VPWR VGND VPWR VGND sky130_ef_sc_hd__decap_12
XPHY_EDGE_ROW_7_Left_45 VGND VGND VPWR VPWR sky130_fd_sc_hd__decap_3
X_785_ clknet_3_0__leaf_CLK _004_ net66 VGND VGND VPWR VPWR CLK_counter\[13\] sky130_fd_sc_hd__dfrtp_1
XFILLER_33_193 VPWR VGND VPWR VGND sky130_ef_sc_hd__decap_12
Xoutput27 net27 VGND VGND VPWR VPWR CF sky130_fd_sc_hd__buf_2
Xoutput38 net38 VGND VGND VPWR VPWR LED[1] sky130_fd_sc_hd__buf_2
Xoutput16 net16 VGND VGND VPWR VPWR AN[2] sky130_fd_sc_hd__buf_2
X_570_ net62 _247_ _250_ VGND VGND VPWR VPWR _251_ sky130_fd_sc_hd__or3_1
XFILLER_31_119 VGND VGND VPWR VPWR sky130_fd_sc_hd__decap_3
X_699_ CLK2_counter\[26\] _329_ CLK2_counter\[27\] VGND VGND VPWR VPWR _332_ sky130_fd_sc_hd__a21o_1
XFILLER_24_171 VGND VGND VPWR VPWR sky130_fd_sc_hd__fill_1
X_768_ clknet_3_5__leaf_CLK _065_ net71 VGND VGND VPWR VPWR attempt_count\[1\] sky130_fd_sc_hd__dfrtp_2
XPHY_EDGE_ROW_24_Right_24 VGND VGND VPWR VPWR sky130_fd_sc_hd__decap_3
XFILLER_21_163 VGND VGND VPWR VPWR sky130_fd_sc_hd__decap_4
XPHY_EDGE_ROW_15_Right_15 VGND VGND VPWR VPWR sky130_fd_sc_hd__decap_3
XFILLER_13_108 VGND VGND VPWR VPWR sky130_fd_sc_hd__decap_4
XPHY_EDGE_ROW_33_Right_33 VGND VGND VPWR VPWR sky130_fd_sc_hd__decap_3
XFILLER_16_93 VGND VGND VPWR VPWR sky130_fd_sc_hd__fill_1
XFILLER_12_141 VGND VGND VPWR VPWR sky130_fd_sc_hd__decap_8
XFILLER_12_130 VGND VGND VPWR VPWR sky130_fd_sc_hd__decap_8
X_484_ net88 _190_ net48 VGND VGND VPWR VPWR _193_ sky130_fd_sc_hd__o21ai_1
X_622_ net54 _169_ _279_ VGND VGND VPWR VPWR _280_ sky130_fd_sc_hd__and3_1
X_553_ net64 CLK2_counter\[0\] VGND VGND VPWR VPWR _238_ sky130_fd_sc_hd__nand2_1
XFILLER_12_29 VGND VGND VPWR VPWR sky130_fd_sc_hd__decap_6
XFILLER_37_15 VPWR VGND VPWR VGND sky130_ef_sc_hd__decap_12
XPHY_EDGE_ROW_36_Left_74 VGND VGND VPWR VPWR sky130_fd_sc_hd__decap_3
X_536_ CLK_counter\[29\] _225_ VGND VGND VPWR VPWR _227_ sky130_fd_sc_hd__and2_1
XPHY_EDGE_ROW_20_Left_58 VGND VGND VPWR VPWR sky130_fd_sc_hd__decap_3
X_605_ attempt_count\[0\] net61 VGND VGND VPWR VPWR _276_ sky130_fd_sc_hd__nand2_1
XFILLER_4_41 VGND VGND VPWR VPWR sky130_fd_sc_hd__decap_6
XFILLER_4_85 VPWR VGND VPWR VGND sky130_ef_sc_hd__decap_12
X_398_ net60 net59 net58 VGND VGND VPWR VPWR _122_ sky130_fd_sc_hd__nor3_1
X_467_ CLK_counter\[6\] _179_ VGND VGND VPWR VPWR _181_ sky130_fd_sc_hd__and2_1
Xfanout73 net74 VGND VGND VPWR VPWR net73 sky130_fd_sc_hd__clkbuf_4
Xfanout51 net52 VGND VGND VPWR VPWR net51 sky130_fd_sc_hd__clkbuf_2
Xfanout62 CLK2_counter\[2\] VGND VGND VPWR VPWR net62 sky130_fd_sc_hd__buf_2
XFILLER_34_27 VGND VGND VPWR VPWR sky130_fd_sc_hd__fill_1
X_519_ net82 _214_ _215_ VGND VGND VPWR VPWR _015_ sky130_fd_sc_hd__a21oi_1
Xclkload4 clknet_3_5__leaf_CLK VGND VGND VPWR VPWR clkload4/Y sky130_fd_sc_hd__clkinvlp_4
XFILLER_37_169 VPWR VGND VPWR VGND sky130_ef_sc_hd__decap_12
XFILLER_37_125 VPWR VGND VPWR VGND sky130_ef_sc_hd__decap_12
XPHY_EDGE_ROW_23_Left_61 VGND VGND VPWR VPWR sky130_fd_sc_hd__decap_3
XFILLER_20_29 VGND VGND VPWR VPWR sky130_fd_sc_hd__fill_2
XFILLER_28_147 VGND VGND VPWR VPWR sky130_fd_sc_hd__fill_1
Xhold16 CLK_counter\[31\] VGND VGND VPWR VPWR net93 sky130_fd_sc_hd__dlygate4sd3_1
XFILLER_35_81 VPWR VGND VPWR VGND sky130_ef_sc_hd__decap_12
XFILLER_34_139 VGND VGND VPWR VPWR sky130_fd_sc_hd__fill_1
XFILLER_32_3 VPWR VGND VPWR VGND sky130_ef_sc_hd__decap_12
XFILLER_19_169 VGND VGND VPWR VPWR sky130_fd_sc_hd__decap_8
XFILLER_19_125 VPWR VGND VPWR VGND sky130_ef_sc_hd__decap_12
X_784_ clknet_3_0__leaf_CLK _003_ net66 VGND VGND VPWR VPWR CLK_counter\[12\] sky130_fd_sc_hd__dfrtp_1
XFILLER_33_161 VGND VGND VPWR VPWR sky130_fd_sc_hd__decap_6
XFILLER_31_28 VGND VGND VPWR VPWR sky130_fd_sc_hd__fill_2
Xoutput39 net39 VGND VGND VPWR VPWR LED[2] sky130_fd_sc_hd__buf_2
Xoutput17 net17 VGND VGND VPWR VPWR AN[3] sky130_fd_sc_hd__buf_2
Xoutput28 net28 VGND VGND VPWR VPWR CG sky130_fd_sc_hd__buf_2
XFILLER_21_50 VGND VGND VPWR VPWR sky130_fd_sc_hd__decap_6
X_767_ clknet_3_5__leaf_CLK _064_ net71 VGND VGND VPWR VPWR attempt_count\[0\] sky130_fd_sc_hd__dfrtp_2
X_698_ net51 _330_ _331_ VGND VGND VPWR VPWR _058_ sky130_fd_sc_hd__and3_1
XFILLER_30_197 VPWR VGND VPWR VGND sky130_ef_sc_hd__decap_12
XFILLER_30_186 VGND VGND VPWR VPWR sky130_fd_sc_hd__decap_8
X_483_ CLK_counter\[11\] CLK_counter\[10\] _166_ _184_ VGND VGND VPWR VPWR _192_ sky130_fd_sc_hd__and4_1
X_621_ _078_ _238_ VGND VGND VPWR VPWR _279_ sky130_fd_sc_hd__nor2_1
X_552_ net64 CLK2_counter\[0\] VGND VGND VPWR VPWR _237_ sky130_fd_sc_hd__and2_1
XFILLER_37_27 VGND VGND VPWR VPWR sky130_fd_sc_hd__fill_1
XTAP_TAPCELL_ROW_11_118 VGND VPWR sky130_fd_sc_hd__tapvpwrvgnd_1
XFILLER_5_149 VGND VGND VPWR VPWR sky130_fd_sc_hd__fill_1
XFILLER_7_190 VGND VGND VPWR VPWR sky130_fd_sc_hd__decap_4
X_535_ CLK_counter\[29\] _225_ VGND VGND VPWR VPWR _226_ sky130_fd_sc_hd__or2_1
XFILLER_17_201 VGND VGND VPWR VPWR sky130_fd_sc_hd__decap_3
X_604_ attempt_count\[3\] _275_ attempt_count\[4\] VGND VGND VPWR VPWR net38 sky130_fd_sc_hd__a21oi_1
X_466_ _179_ _180_ net47 VGND VGND VPWR VPWR _027_ sky130_fd_sc_hd__and3b_1
XFILLER_4_182 VGND VGND VPWR VPWR sky130_fd_sc_hd__decap_8
X_397_ _113_ _118_ _119_ _120_ VGND VGND VPWR VPWR _121_ sky130_fd_sc_hd__or4b_1
Xfanout74 net75 VGND VGND VPWR VPWR net74 sky130_fd_sc_hd__clkbuf_4
Xfanout52 net53 VGND VGND VPWR VPWR net52 sky130_fd_sc_hd__clkbuf_2
Xfanout63 CLK2_counter\[2\] VGND VGND VPWR VPWR net63 sky130_fd_sc_hd__dlymetal6s2s_1
XFILLER_1_185 VGND VGND VPWR VPWR sky130_fd_sc_hd__decap_4
XTAP_TAPCELL_ROW_0_76 VGND VPWR sky130_fd_sc_hd__tapvpwrvgnd_1
X_518_ CLK_counter\[23\] _214_ net49 VGND VGND VPWR VPWR _215_ sky130_fd_sc_hd__o21ai_1
XFILLER_18_29 VGND VGND VPWR VPWR sky130_fd_sc_hd__decap_8
Xclkbuf_3_5__f_CLK clknet_0_CLK VGND VGND VPWR VPWR clknet_3_5__leaf_CLK sky130_fd_sc_hd__clkbuf_16
X_449_ _163_ _164_ _167_ _168_ VGND VGND VPWR VPWR _169_ sky130_fd_sc_hd__and4b_1
Xclkload5 clknet_3_6__leaf_CLK VGND VGND VPWR VPWR clkload5/Y sky130_fd_sc_hd__clkinvlp_4
XFILLER_37_137 VGND VGND VPWR VPWR sky130_fd_sc_hd__decap_3
XFILLER_28_137 VGND VGND VPWR VPWR sky130_fd_sc_hd__decap_3
XFILLER_28_104 VGND VGND VPWR VPWR sky130_fd_sc_hd__fill_2
Xhold17 _024_ VGND VGND VPWR VPWR net94 sky130_fd_sc_hd__dlygate4sd3_1
XFILLER_35_93 VPWR VGND VPWR VGND sky130_ef_sc_hd__decap_12
XFILLER_27_181 VGND VGND VPWR VPWR sky130_fd_sc_hd__fill_2
XFILLER_19_137 VGND VGND VPWR VPWR sky130_fd_sc_hd__decap_8
X_783_ clknet_3_0__leaf_CLK _002_ net66 VGND VGND VPWR VPWR CLK_counter\[11\] sky130_fd_sc_hd__dfrtp_1
XFILLER_10_96 VGND VGND VPWR VPWR sky130_fd_sc_hd__decap_6
XFILLER_10_85 VGND VGND VPWR VPWR sky130_fd_sc_hd__fill_1
Xoutput29 net29 VGND VGND VPWR VPWR LED16_G sky130_fd_sc_hd__buf_2
Xoutput18 net18 VGND VGND VPWR VPWR AN[4] sky130_fd_sc_hd__buf_2
XFILLER_24_184 VPWR VGND VPWR VGND sky130_ef_sc_hd__decap_12
X_697_ CLK2_counter\[26\] _329_ VGND VGND VPWR VPWR _331_ sky130_fd_sc_hd__nand2_1
XFILLER_30_165 VGND VGND VPWR VPWR sky130_fd_sc_hd__decap_6
X_766_ clknet_3_3__leaf_CLK _063_ net74 VGND VGND VPWR VPWR CLK2_counter\[31\] sky130_fd_sc_hd__dfrtp_1
XFILLER_15_195 VGND VGND VPWR VPWR sky130_fd_sc_hd__decap_8
XFILLER_7_53 VGND VGND VPWR VPWR sky130_fd_sc_hd__decap_3
XFILLER_26_29 VGND VGND VPWR VPWR sky130_fd_sc_hd__fill_1
X_551_ _107_ _231_ _233_ VGND VGND VPWR VPWR net21 sky130_fd_sc_hd__a21o_1
XPHY_EDGE_ROW_5_Right_5 VGND VGND VPWR VPWR sky130_fd_sc_hd__decap_3
X_620_ net64 _171_ _250_ _278_ VGND VGND VPWR VPWR _033_ sky130_fd_sc_hd__a22o_1
X_749_ clknet_3_7__leaf_CLK _046_ net74 VGND VGND VPWR VPWR CLK2_counter\[14\] sky130_fd_sc_hd__dfrtp_1
XFILLER_16_40 VGND VGND VPWR VPWR sky130_fd_sc_hd__decap_3
X_482_ _190_ _191_ VGND VGND VPWR VPWR _001_ sky130_fd_sc_hd__nor2_1
XTAP_TAPCELL_ROW_11_119 VGND VPWR sky130_fd_sc_hd__tapvpwrvgnd_1
X_534_ _225_ net49 _224_ VGND VGND VPWR VPWR _020_ sky130_fd_sc_hd__and3b_1
XFILLER_27_50 VGND VGND VPWR VPWR sky130_fd_sc_hd__decap_6
X_603_ attempt_count\[0\] attempt_count\[1\] net61 VGND VGND VPWR VPWR _275_ sky130_fd_sc_hd__and3_1
X_465_ CLK_counter\[4\] _175_ CLK_counter\[5\] VGND VGND VPWR VPWR _180_ sky130_fd_sc_hd__a21o_1
XFILLER_5_106 VGND VGND VPWR VPWR sky130_fd_sc_hd__fill_1
X_396_ password\[2\] _084_ _085_ net10 VGND VGND VPWR VPWR _120_ sky130_fd_sc_hd__o22a_1
Xfanout75 net5 VGND VGND VPWR VPWR net75 sky130_fd_sc_hd__clkbuf_2
Xfanout53 _157_ VGND VGND VPWR VPWR net53 sky130_fd_sc_hd__clkbuf_2
XFILLER_14_216 VGND VGND VPWR VPWR sky130_fd_sc_hd__fill_1
Xfanout64 CLK2_counter\[1\] VGND VGND VPWR VPWR net64 sky130_fd_sc_hd__clkbuf_2
X_517_ _213_ _214_ net49 VGND VGND VPWR VPWR _014_ sky130_fd_sc_hd__nor3b_1
X_379_ CLK2_counter\[13\] _102_ VGND VGND VPWR VPWR _103_ sky130_fd_sc_hd__or2_1
X_448_ CLK_counter\[9\] CLK_counter\[8\] CLK_counter\[15\] CLK_counter\[14\] VGND
+ VGND VPWR VPWR _168_ sky130_fd_sc_hd__and4_1
XTAP_TAPCELL_ROW_0_77 VGND VPWR sky130_fd_sc_hd__tapvpwrvgnd_1
XFILLER_34_29 VPWR VGND VPWR VGND sky130_ef_sc_hd__decap_12
Xclkload6 clknet_3_7__leaf_CLK VGND VGND VPWR VPWR clkload6/Y sky130_fd_sc_hd__clkinv_2
XFILLER_1_77 VGND VGND VPWR VPWR sky130_fd_sc_hd__fill_2
XFILLER_1_55 VGND VGND VPWR VPWR sky130_fd_sc_hd__fill_1
XFILLER_29_29 VGND VGND VPWR VPWR sky130_fd_sc_hd__fill_1
Xhold18 CLK_counter\[18\] VGND VGND VPWR VPWR net95 sky130_fd_sc_hd__dlygate4sd3_1
X_782_ clknet_3_0__leaf_CLK _001_ net65 VGND VGND VPWR VPWR CLK_counter\[10\] sky130_fd_sc_hd__dfrtp_1
XFILLER_18_3 VGND VGND VPWR VPWR sky130_fd_sc_hd__decap_6
Xoutput19 net19 VGND VGND VPWR VPWR AN[5] sky130_fd_sc_hd__buf_2
X_696_ CLK2_counter\[26\] _329_ VGND VGND VPWR VPWR _330_ sky130_fd_sc_hd__or2_1
X_765_ clknet_3_3__leaf_CLK _062_ net69 VGND VGND VPWR VPWR CLK2_counter\[30\] sky130_fd_sc_hd__dfrtp_1
XFILLER_15_141 VGND VGND VPWR VPWR sky130_fd_sc_hd__decap_6
XTAP_TAPCELL_ROW_37_209 VGND VPWR sky130_fd_sc_hd__tapvpwrvgnd_1
XPHY_EDGE_ROW_20_Right_20 VGND VGND VPWR VPWR sky130_fd_sc_hd__decap_3
X_817_ net15 VGND VGND VPWR VPWR net14 sky130_fd_sc_hd__clkbuf_1
XFILLER_16_85 VGND VGND VPWR VPWR sky130_fd_sc_hd__decap_3
XTAP_TAPCELL_ROW_14_128 VGND VPWR sky130_fd_sc_hd__tapvpwrvgnd_1
XFILLER_12_111 VGND VGND VPWR VPWR sky130_fd_sc_hd__fill_2
XPHY_EDGE_ROW_11_Right_11 VGND VGND VPWR VPWR sky130_fd_sc_hd__decap_3
X_481_ net97 _189_ net48 VGND VGND VPWR VPWR _191_ sky130_fd_sc_hd__o21ai_1
X_550_ _233_ _236_ VGND VGND VPWR VPWR net20 sky130_fd_sc_hd__or2_1
XFILLER_8_115 VGND VGND VPWR VPWR sky130_fd_sc_hd__fill_2
XFILLER_37_29 VPWR VGND VPWR VGND sky130_ef_sc_hd__decap_12
X_679_ net52 _318_ VGND VGND VPWR VPWR _052_ sky130_fd_sc_hd__and2_1
X_748_ clknet_3_7__leaf_CLK _045_ net73 VGND VGND VPWR VPWR CLK2_counter\[13\] sky130_fd_sc_hd__dfrtp_1
X_533_ CLK_counter\[27\] CLK_counter\[26\] CLK_counter\[28\] _218_ VGND VGND VPWR
+ VPWR _225_ sky130_fd_sc_hd__and4_1
X_602_ attempt_count\[1\] attempt_count\[3\] net61 attempt_count\[4\] VGND VGND VPWR
+ VPWR net39 sky130_fd_sc_hd__a31oi_1
X_464_ CLK_counter\[5\] CLK_counter\[4\] _175_ VGND VGND VPWR VPWR _179_ sky130_fd_sc_hd__and3_1
XFILLER_5_129 VGND VGND VPWR VPWR sky130_fd_sc_hd__fill_2
XFILLER_4_173 VGND VGND VPWR VPWR sky130_fd_sc_hd__fill_2
X_395_ password\[2\] _084_ _085_ net10 VGND VGND VPWR VPWR _119_ sky130_fd_sc_hd__a22o_1
XFILLER_13_75 VPWR VGND VPWR VGND sky130_ef_sc_hd__decap_12
Xfanout65 net67 VGND VGND VPWR VPWR net65 sky130_fd_sc_hd__clkbuf_4
X_516_ CLK_counter\[21\] CLK_counter\[20\] CLK_counter\[22\] _208_ VGND VGND VPWR
+ VPWR _214_ sky130_fd_sc_hd__and4_1
XFILLER_20_209 VGND VGND VPWR VPWR sky130_fd_sc_hd__fill_2
X_378_ CLK2_counter\[15\] CLK2_counter\[14\] VGND VGND VPWR VPWR _102_ sky130_fd_sc_hd__or2_1
XFILLER_9_210 VGND VGND VPWR VPWR sky130_fd_sc_hd__decap_4
XTAP_TAPCELL_ROW_0_78 VGND VPWR sky130_fd_sc_hd__tapvpwrvgnd_1
X_447_ CLK_counter\[1\] CLK_counter\[0\] CLK_counter\[3\] CLK_counter\[2\] VGND VGND
+ VPWR VPWR _167_ sky130_fd_sc_hd__nor4_1
XFILLER_28_117 VPWR VGND VPWR VGND sky130_ef_sc_hd__decap_12
Xhold19 CLK_counter\[13\] VGND VGND VPWR VPWR net96 sky130_fd_sc_hd__dlygate4sd3_1
XFILLER_34_109 VPWR VGND VPWR VGND sky130_ef_sc_hd__decap_12
X_781_ clknet_3_0__leaf_CLK _031_ net65 VGND VGND VPWR VPWR CLK_counter\[9\] sky130_fd_sc_hd__dfrtp_1
XFILLER_10_43 VGND VGND VPWR VPWR sky130_fd_sc_hd__decap_4
XPHY_EDGE_ROW_27_Left_65 VGND VGND VPWR VPWR sky130_fd_sc_hd__decap_3
XPHY_EDGE_ROW_11_Left_49 VGND VGND VPWR VPWR sky130_fd_sc_hd__decap_3
XFILLER_24_197 VPWR VGND VPWR VGND sky130_ef_sc_hd__decap_12
X_695_ _329_ net52 _327_ VGND VGND VPWR VPWR _057_ sky130_fd_sc_hd__and3b_1
X_764_ clknet_3_3__leaf_CLK _061_ net69 VGND VGND VPWR VPWR CLK2_counter\[29\] sky130_fd_sc_hd__dfrtp_1
XFILLER_7_33 VPWR VGND VPWR VGND sky130_ef_sc_hd__decap_12
XFILLER_30_3 VGND VGND VPWR VPWR sky130_fd_sc_hd__decap_4
XFILLER_21_189 VPWR VGND VPWR VGND sky130_ef_sc_hd__decap_12
XFILLER_21_167 VGND VGND VPWR VPWR sky130_fd_sc_hd__fill_1
XFILLER_32_85 VPWR VGND VPWR VGND sky130_ef_sc_hd__decap_12
XFILLER_29_201 VPWR VGND VPWR VGND sky130_ef_sc_hd__decap_12
XTAP_TAPCELL_ROW_14_129 VGND VPWR sky130_fd_sc_hd__tapvpwrvgnd_1
XFILLER_12_178 VGND VGND VPWR VPWR sky130_fd_sc_hd__fill_1
X_480_ CLK_counter\[10\] _166_ _184_ VGND VGND VPWR VPWR _190_ sky130_fd_sc_hd__and3_1
XFILLER_8_149 VGND VGND VPWR VPWR sky130_fd_sc_hd__decap_3
X_678_ CLK2_counter\[20\] _317_ VGND VGND VPWR VPWR _318_ sky130_fd_sc_hd__xor2_1
X_747_ clknet_3_7__leaf_CLK _044_ net73 VGND VGND VPWR VPWR CLK2_counter\[12\] sky130_fd_sc_hd__dfrtp_1
XPHY_EDGE_ROW_14_Left_52 VGND VGND VPWR VPWR sky130_fd_sc_hd__decap_3
X_601_ attempt_count\[0\] attempt_count\[1\] VGND VGND VPWR VPWR _274_ sky130_fd_sc_hd__nand2_1
X_532_ CLK_counter\[28\] _222_ VGND VGND VPWR VPWR _224_ sky130_fd_sc_hd__or2_1
X_463_ _171_ _177_ _178_ VGND VGND VPWR VPWR _026_ sky130_fd_sc_hd__and3_1
XFILLER_4_141 VPWR VGND VPWR VGND sky130_ef_sc_hd__decap_12
X_394_ _114_ _115_ _116_ _117_ VGND VGND VPWR VPWR _118_ sky130_fd_sc_hd__or4_1
X_515_ CLK_counter\[21\] _210_ CLK_counter\[22\] VGND VGND VPWR VPWR _213_ sky130_fd_sc_hd__a21oi_1
X_377_ CLK2_counter\[12\] CLK2_counter\[9\] CLK2_counter\[8\] VGND VGND VPWR VPWR
+ _101_ sky130_fd_sc_hd__and3_1
Xfanout66 net67 VGND VGND VPWR VPWR net66 sky130_fd_sc_hd__clkbuf_2
XFILLER_13_98 VGND VGND VPWR VPWR sky130_fd_sc_hd__decap_6
XFILLER_13_87 VGND VGND VPWR VPWR sky130_fd_sc_hd__decap_8
XFILLER_13_65 VGND VGND VPWR VPWR sky130_fd_sc_hd__fill_2
XFILLER_13_54 VGND VGND VPWR VPWR sky130_fd_sc_hd__fill_2
X_446_ CLK_counter\[9\] CLK_counter\[8\] VGND VGND VPWR VPWR _166_ sky130_fd_sc_hd__and2_1
XFILLER_1_122 VGND VGND VPWR VPWR sky130_fd_sc_hd__fill_1
XFILLER_1_111 VGND VGND VPWR VPWR sky130_fd_sc_hd__fill_1
XTAP_TAPCELL_ROW_0_79 VGND VPWR sky130_fd_sc_hd__tapvpwrvgnd_1
XFILLER_8_3 VGND VGND VPWR VPWR sky130_fd_sc_hd__decap_8
X_429_ CLK2_counter\[10\] CLK2_counter\[11\] CLK2_counter\[12\] VGND VGND VPWR VPWR
+ _150_ sky130_fd_sc_hd__o21a_1
XFILLER_36_195 VGND VGND VPWR VPWR sky130_fd_sc_hd__fill_1
XFILLER_28_129 VGND VGND VPWR VPWR sky130_fd_sc_hd__decap_8
XFILLER_19_31 VGND VGND VPWR VPWR sky130_fd_sc_hd__fill_1
XFILLER_10_66 VGND VGND VPWR VPWR sky130_fd_sc_hd__fill_1
XFILLER_10_55 VGND VGND VPWR VPWR sky130_fd_sc_hd__decap_4
Xinput1 BTNC VGND VGND VPWR VPWR net1 sky130_fd_sc_hd__dlymetal6s2s_1
X_780_ clknet_3_1__leaf_CLK _030_ net65 VGND VGND VPWR VPWR CLK_counter\[8\] sky130_fd_sc_hd__dfrtp_1
XFILLER_35_30 VPWR VGND VPWR VGND sky130_ef_sc_hd__decap_12
XFILLER_19_97 VGND VGND VPWR VPWR sky130_fd_sc_hd__fill_1
XPHY_EDGE_ROW_2_Left_40 VGND VGND VPWR VPWR sky130_fd_sc_hd__decap_3
XFILLER_0_209 VGND VGND VPWR VPWR sky130_fd_sc_hd__fill_2
X_694_ CLK2_counter\[23\] _323_ _328_ VGND VGND VPWR VPWR _329_ sky130_fd_sc_hd__and3_1
X_763_ clknet_3_6__leaf_CLK _060_ net69 VGND VGND VPWR VPWR CLK2_counter\[28\] sky130_fd_sc_hd__dfrtp_1
XFILLER_15_110 VGND VGND VPWR VPWR sky130_fd_sc_hd__fill_2
XFILLER_30_179 VGND VGND VPWR VPWR sky130_fd_sc_hd__fill_2
XFILLER_23_3 VPWR VGND VPWR VGND sky130_ef_sc_hd__decap_12
XFILLER_21_113 VGND VGND VPWR VPWR sky130_fd_sc_hd__decap_6
XFILLER_7_45 VGND VGND VPWR VPWR sky130_fd_sc_hd__decap_8
XFILLER_32_97 VGND VGND VPWR VPWR sky130_fd_sc_hd__decap_6
XFILLER_29_213 VGND VGND VPWR VPWR sky130_fd_sc_hd__decap_4
XFILLER_16_32 VGND VGND VPWR VPWR sky130_fd_sc_hd__decap_8
XFILLER_8_128 VPWR VGND VPWR VGND sky130_ef_sc_hd__decap_12
XFILLER_35_205 VPWR VGND VPWR VGND sky130_ef_sc_hd__decap_12
X_677_ _317_ net52 _315_ VGND VGND VPWR VPWR _051_ sky130_fd_sc_hd__and3b_1
X_746_ clknet_3_5__leaf_CLK _043_ net71 VGND VGND VPWR VPWR CLK2_counter\[11\] sky130_fd_sc_hd__dfrtp_1
XPHY_EDGE_ROW_9_Right_9 VGND VGND VPWR VPWR sky130_fd_sc_hd__decap_3
X_531_ net84 _220_ _223_ VGND VGND VPWR VPWR _019_ sky130_fd_sc_hd__o21a_1
X_600_ attempt_count\[3\] net61 attempt_count\[4\] VGND VGND VPWR VPWR net41 sky130_fd_sc_hd__a21oi_1
X_462_ CLK_counter\[4\] _175_ VGND VGND VPWR VPWR _178_ sky130_fd_sc_hd__or2_1
X_393_ password\[6\] _086_ password\[7\] _087_ VGND VGND VPWR VPWR _117_ sky130_fd_sc_hd__a2bb2o_1
XFILLER_4_24 VGND VGND VPWR VPWR sky130_fd_sc_hd__decap_4
XFILLER_4_153 VPWR VGND VPWR VGND sky130_ef_sc_hd__decap_12
XFILLER_23_219 VGND VGND VPWR VPWR sky130_fd_sc_hd__fill_2
Xclkbuf_3_0__f_CLK clknet_0_CLK VGND VGND VPWR VPWR clknet_3_0__leaf_CLK sky130_fd_sc_hd__clkbuf_16
X_729_ net8 net85 _349_ VGND VGND VPWR VPWR _071_ sky130_fd_sc_hd__mux2_1
X_514_ net79 _210_ _212_ VGND VGND VPWR VPWR _013_ sky130_fd_sc_hd__a21oi_1
Xfanout67 net75 VGND VGND VPWR VPWR net67 sky130_fd_sc_hd__clkbuf_4
XFILLER_14_208 VGND VGND VPWR VPWR sky130_fd_sc_hd__fill_2
XFILLER_1_189 VGND VGND VPWR VPWR sky130_fd_sc_hd__fill_1
X_445_ CLK_counter\[15\] CLK_counter\[14\] VGND VGND VPWR VPWR _165_ sky130_fd_sc_hd__and2_1
X_376_ CLK2_counter\[9\] CLK2_counter\[8\] VGND VGND VPWR VPWR _100_ sky130_fd_sc_hd__nand2_1
XSSS_76 VGND VGND VPWR VPWR SSS_76/HI LED16_B sky130_fd_sc_hd__conb_1
X_428_ CLK2_counter\[7\] _148_ _104_ VGND VGND VPWR VPWR _149_ sky130_fd_sc_hd__a21o_1
X_359_ password\[4\] VGND VGND VPWR VPWR _085_ sky130_fd_sc_hd__inv_2
XFILLER_36_141 VPWR VGND VPWR VGND sky130_ef_sc_hd__decap_12
Xinput2 BTNL VGND VGND VPWR VPWR net2 sky130_fd_sc_hd__buf_1
XFILLER_35_42 VPWR VGND VPWR VGND sky130_ef_sc_hd__decap_12
XFILLER_27_141 VPWR VGND VPWR VGND sky130_ef_sc_hd__decap_12
XFILLER_19_108 VGND VGND VPWR VPWR sky130_fd_sc_hd__decap_4
XFILLER_33_111 VGND VGND VPWR VPWR sky130_fd_sc_hd__fill_1
XTAP_TAPCELL_ROW_28_180 VGND VPWR sky130_fd_sc_hd__tapvpwrvgnd_1
X_693_ CLK2_counter\[25\] CLK2_counter\[24\] VGND VGND VPWR VPWR _328_ sky130_fd_sc_hd__and2_1
X_762_ clknet_3_6__leaf_CLK _059_ net74 VGND VGND VPWR VPWR CLK2_counter\[27\] sky130_fd_sc_hd__dfrtp_1
XFILLER_15_100 VGND VGND VPWR VPWR sky130_fd_sc_hd__fill_1
XTAP_TAPCELL_ROW_17_139 VGND VPWR sky130_fd_sc_hd__tapvpwrvgnd_1
XFILLER_7_57 VGND VGND VPWR VPWR sky130_fd_sc_hd__decap_4
XFILLER_16_66 VPWR VGND VPWR VGND sky130_ef_sc_hd__decap_12
XTAP_TAPCELL_ROW_8_107 VGND VPWR sky130_fd_sc_hd__tapvpwrvgnd_1
XFILLER_8_107 VGND VGND VPWR VPWR sky130_fd_sc_hd__decap_8
XFILLER_35_217 VGND VGND VPWR VPWR sky130_fd_sc_hd__fill_1
XFILLER_32_76 VGND VGND VPWR VPWR sky130_fd_sc_hd__decap_8
X_676_ _312_ _316_ VGND VGND VPWR VPWR _317_ sky130_fd_sc_hd__and2_1
XFILLER_20_180 VPWR VGND VPWR VGND sky130_ef_sc_hd__decap_12
X_745_ clknet_3_5__leaf_CLK _042_ net69 VGND VGND VPWR VPWR CLK2_counter\[10\] sky130_fd_sc_hd__dfrtp_2
XFILLER_11_191 VGND VGND VPWR VPWR sky130_fd_sc_hd__fill_1
XFILLER_11_180 VGND VGND VPWR VPWR sky130_fd_sc_hd__fill_2
X_814_ clknet_3_4__leaf_CLK next_state\[2\] net72 VGND VGND VPWR VPWR state\[2\] sky130_fd_sc_hd__dfrtp_1
XFILLER_32_209 VPWR VGND VPWR VGND sky130_ef_sc_hd__decap_12
X_530_ _222_ net53 VGND VGND VPWR VPWR _223_ sky130_fd_sc_hd__and2b_1
X_392_ password\[1\] _083_ password\[6\] _086_ VGND VGND VPWR VPWR _116_ sky130_fd_sc_hd__a22o_1
X_461_ CLK_counter\[4\] _175_ VGND VGND VPWR VPWR _177_ sky130_fd_sc_hd__nand2_1
XFILLER_4_110 VPWR VGND VPWR VGND sky130_ef_sc_hd__decap_12
XFILLER_4_165 VGND VGND VPWR VPWR sky130_fd_sc_hd__decap_8
X_659_ CLK2_counter\[14\] _303_ VGND VGND VPWR VPWR _305_ sky130_fd_sc_hd__nand2_1
X_728_ net7 net90 _349_ VGND VGND VPWR VPWR _070_ sky130_fd_sc_hd__mux2_1
Xfanout68 net70 VGND VGND VPWR VPWR net68 sky130_fd_sc_hd__clkbuf_4
XFILLER_13_45 VGND VGND VPWR VPWR sky130_fd_sc_hd__fill_2
X_513_ CLK_counter\[21\] _210_ net49 VGND VGND VPWR VPWR _212_ sky130_fd_sc_hd__o21ai_1
X_375_ CLK2_counter\[9\] CLK2_counter\[8\] VGND VGND VPWR VPWR _099_ sky130_fd_sc_hd__and2_1
X_444_ CLK_counter\[5\] CLK_counter\[7\] CLK_counter\[6\] CLK_counter\[4\] VGND VGND
+ VPWR VPWR _164_ sky130_fd_sc_hd__and4bb_1
XFILLER_37_109 VGND VGND VPWR VPWR sky130_fd_sc_hd__decap_3
XSSS_77 VGND VGND VPWR VPWR DP SSS_77/LO sky130_fd_sc_hd__conb_1
X_427_ CLK2_counter\[3\] _107_ _108_ VGND VGND VPWR VPWR _148_ sky130_fd_sc_hd__a21o_1
X_358_ net8 VGND VGND VPWR VPWR _084_ sky130_fd_sc_hd__inv_2
XFILLER_36_197 VPWR VGND VPWR VGND sky130_ef_sc_hd__decap_12
XFILLER_36_153 VPWR VGND VPWR VGND sky130_ef_sc_hd__decap_12
XPHY_EDGE_ROW_27_Right_27 VGND VGND VPWR VPWR sky130_fd_sc_hd__decap_3
XPHY_EDGE_ROW_18_Right_18 VGND VGND VPWR VPWR sky130_fd_sc_hd__decap_3
Xinput3 BTNR VGND VGND VPWR VPWR net3 sky130_fd_sc_hd__clkbuf_1
XPHY_EDGE_ROW_36_Right_36 VGND VGND VPWR VPWR sky130_fd_sc_hd__decap_3
XFILLER_35_54 VGND VGND VPWR VPWR sky130_fd_sc_hd__fill_2
XFILLER_27_153 VPWR VGND VPWR VGND sky130_ef_sc_hd__decap_12
XFILLER_33_167 VGND VGND VPWR VPWR sky130_fd_sc_hd__fill_1
XFILLER_18_197 VGND VGND VPWR VPWR sky130_fd_sc_hd__decap_8
X_761_ clknet_3_6__leaf_CLK _058_ net74 VGND VGND VPWR VPWR CLK2_counter\[26\] sky130_fd_sc_hd__dfrtp_1
X_692_ CLK2_counter\[24\] CLK2_counter\[23\] _323_ CLK2_counter\[25\] VGND VGND VPWR
+ VPWR _327_ sky130_fd_sc_hd__a31o_1
Xmax_cap54 net55 VGND VGND VPWR VPWR net54 sky130_fd_sc_hd__clkbuf_1
XTAP_TAPCELL_ROW_8_108 VGND VPWR sky130_fd_sc_hd__tapvpwrvgnd_1
XFILLER_32_44 VPWR VGND VPWR VGND sky130_ef_sc_hd__decap_12
XFILLER_32_33 VGND VGND VPWR VPWR sky130_fd_sc_hd__decap_4
X_675_ CLK2_counter\[19\] CLK2_counter\[18\] VGND VGND VPWR VPWR _316_ sky130_fd_sc_hd__and2_1
XFILLER_20_192 VGND VGND VPWR VPWR sky130_fd_sc_hd__decap_4
XFILLER_16_78 VGND VGND VPWR VPWR sky130_fd_sc_hd__decap_6
X_744_ clknet_3_1__leaf_CLK _041_ net67 VGND VGND VPWR VPWR CLK2_counter\[9\] sky130_fd_sc_hd__dfrtp_2
X_813_ clknet_3_5__leaf_CLK next_state\[1\] net72 VGND VGND VPWR VPWR state\[1\] sky130_fd_sc_hd__dfrtp_1
XPHY_EDGE_ROW_0_Right_0 VGND VGND VPWR VPWR sky130_fd_sc_hd__decap_3
X_391_ password\[3\] net9 VGND VGND VPWR VPWR _115_ sky130_fd_sc_hd__xor2_1
X_460_ _175_ _176_ net47 VGND VGND VPWR VPWR _025_ sky130_fd_sc_hd__and3b_1
X_658_ CLK2_counter\[14\] _303_ VGND VGND VPWR VPWR _304_ sky130_fd_sc_hd__nor2_1
X_589_ _154_ _265_ net15 VGND VGND VPWR VPWR _266_ sky130_fd_sc_hd__a21o_1
XFILLER_4_15 VGND VGND VPWR VPWR sky130_fd_sc_hd__decap_4
XFILLER_4_59 VPWR VGND VPWR VGND sky130_ef_sc_hd__decap_12
XFILLER_4_122 VGND VGND VPWR VPWR sky130_fd_sc_hd__fill_2
X_727_ net6 password\[0\] _349_ VGND VGND VPWR VPWR _069_ sky130_fd_sc_hd__mux2_1
Xfanout69 net70 VGND VGND VPWR VPWR net69 sky130_fd_sc_hd__clkbuf_4
XPHY_EDGE_ROW_18_Left_56 VGND VGND VPWR VPWR sky130_fd_sc_hd__decap_3
Xfanout47 net53 VGND VGND VPWR VPWR net47 sky130_fd_sc_hd__buf_2
XFILLER_13_57 VGND VGND VPWR VPWR sky130_fd_sc_hd__decap_8
Xfanout58 state\[2\] VGND VGND VPWR VPWR net58 sky130_fd_sc_hd__clkbuf_2
X_374_ _094_ _095_ _096_ _097_ VGND VGND VPWR VPWR _098_ sky130_fd_sc_hd__or4_1
X_512_ net86 _208_ _211_ VGND VGND VPWR VPWR _012_ sky130_fd_sc_hd__o21a_1
X_443_ CLK_counter\[11\] CLK_counter\[10\] CLK_counter\[13\] CLK_counter\[12\] VGND
+ VGND VPWR VPWR _163_ sky130_fd_sc_hd__or4_1
XFILLER_1_169 VGND VGND VPWR VPWR sky130_fd_sc_hd__decap_4
XFILLER_1_49 VGND VGND VPWR VPWR sky130_fd_sc_hd__decap_6
XFILLER_6_3 VGND VGND VPWR VPWR sky130_fd_sc_hd__decap_6
XFILLER_36_165 VPWR VGND VPWR VGND sky130_ef_sc_hd__decap_12
XFILLER_36_121 VPWR VGND VPWR VGND sky130_ef_sc_hd__decap_12
X_357_ net7 VGND VGND VPWR VPWR _083_ sky130_fd_sc_hd__inv_2
Xinput4 BTNU VGND VGND VPWR VPWR net4 sky130_fd_sc_hd__clkbuf_1
X_426_ _093_ _110_ _147_ VGND VGND VPWR VPWR next_state\[2\] sky130_fd_sc_hd__o21ai_1
XFILLER_27_165 VGND VGND VPWR VPWR sky130_fd_sc_hd__decap_3
XFILLER_27_121 VGND VGND VPWR VPWR sky130_fd_sc_hd__fill_1
XFILLER_19_89 VGND VGND VPWR VPWR sky130_fd_sc_hd__decap_8
XFILLER_33_113 VPWR VGND VPWR VGND sky130_ef_sc_hd__decap_12
X_409_ net1 net2 net57 _126_ _128_ VGND VGND VPWR VPWR _132_ sky130_fd_sc_hd__o2111a_1
XFILLER_2_220 VGND VGND VPWR VPWR sky130_fd_sc_hd__fill_1
Xclkbuf_3_6__f_CLK clknet_0_CLK VGND VGND VPWR VPWR clknet_3_6__leaf_CLK sky130_fd_sc_hd__clkbuf_16
XFILLER_21_68 VGND VGND VPWR VPWR sky130_fd_sc_hd__decap_4
X_760_ clknet_3_6__leaf_CLK _057_ net74 VGND VGND VPWR VPWR CLK2_counter\[25\] sky130_fd_sc_hd__dfrtp_1
X_691_ net51 _326_ VGND VGND VPWR VPWR _056_ sky130_fd_sc_hd__and2_1
XFILLER_30_7 VGND VGND VPWR VPWR sky130_fd_sc_hd__fill_1
Xmax_cap55 net56 VGND VGND VPWR VPWR net55 sky130_fd_sc_hd__clkbuf_1
XPHY_EDGE_ROW_6_Left_44 VGND VGND VPWR VPWR sky130_fd_sc_hd__decap_3
XTAP_TAPCELL_ROW_31_188 VGND VPWR sky130_fd_sc_hd__tapvpwrvgnd_1
XFILLER_21_127 VGND VGND VPWR VPWR sky130_fd_sc_hd__fill_1
XTAP_TAPCELL_ROW_8_109 VGND VPWR sky130_fd_sc_hd__tapvpwrvgnd_1
XFILLER_32_23 VGND VGND VPWR VPWR sky130_fd_sc_hd__fill_1
X_674_ CLK2_counter\[18\] _312_ CLK2_counter\[19\] VGND VGND VPWR VPWR _315_ sky130_fd_sc_hd__a21o_1
X_743_ clknet_3_1__leaf_CLK _040_ net67 VGND VGND VPWR VPWR CLK2_counter\[8\] sky130_fd_sc_hd__dfrtp_1
X_812_ clknet_3_5__leaf_CLK next_state\[0\] net72 VGND VGND VPWR VPWR state\[0\] sky130_fd_sc_hd__dfrtp_1
XFILLER_12_149 VGND VGND VPWR VPWR sky130_fd_sc_hd__fill_1
XFILLER_12_138 VGND VGND VPWR VPWR sky130_fd_sc_hd__fill_2
XFILLER_21_3 VGND VGND VPWR VPWR sky130_fd_sc_hd__fill_1
XFILLER_7_131 VGND VGND VPWR VPWR sky130_fd_sc_hd__fill_2
X_390_ password\[5\] net11 VGND VGND VPWR VPWR _114_ sky130_fd_sc_hd__xor2_1
X_657_ _303_ net52 _302_ VGND VGND VPWR VPWR _045_ sky130_fd_sc_hd__and3b_1
X_588_ CLK2_counter\[10\] _080_ CLK2_counter\[8\] VGND VGND VPWR VPWR _265_ sky130_fd_sc_hd__or3_1
XTAP_TAPCELL_ROW_10_114 VGND VPWR sky130_fd_sc_hd__tapvpwrvgnd_1
X_726_ _145_ _140_ VGND VGND VPWR VPWR _349_ sky130_fd_sc_hd__nand2b_4
Xfanout48 net53 VGND VGND VPWR VPWR net48 sky130_fd_sc_hd__buf_1
Xfanout59 state\[1\] VGND VGND VPWR VPWR net59 sky130_fd_sc_hd__clkbuf_2
XPHY_EDGE_ROW_35_Left_73 VGND VGND VPWR VPWR sky130_fd_sc_hd__decap_3
X_511_ _210_ net49 VGND VGND VPWR VPWR _211_ sky130_fd_sc_hd__and2b_1
X_442_ _158_ _159_ _160_ _161_ VGND VGND VPWR VPWR _162_ sky130_fd_sc_hd__nor4_1
X_373_ CLK2_counter\[19\] CLK2_counter\[18\] CLK2_counter\[17\] CLK2_counter\[16\]
+ VGND VGND VPWR VPWR _097_ sky130_fd_sc_hd__or4_1
X_709_ _334_ _337_ CLK2_counter\[30\] VGND VGND VPWR VPWR _339_ sky130_fd_sc_hd__a21o_1
XFILLER_0_181 VGND VGND VPWR VPWR sky130_fd_sc_hd__decap_4
XFILLER_36_133 VGND VGND VPWR VPWR sky130_fd_sc_hd__decap_6
Xinput5 CPU_RESETN VGND VGND VPWR VPWR net5 sky130_fd_sc_hd__clkbuf_1
XFILLER_14_90 VGND VGND VPWR VPWR sky130_fd_sc_hd__fill_1
X_356_ net1 VGND VGND VPWR VPWR _082_ sky130_fd_sc_hd__inv_2
X_425_ _088_ _127_ _139_ _146_ VGND VGND VPWR VPWR _147_ sky130_fd_sc_hd__and4_1
XFILLER_36_177 VPWR VGND VPWR VGND sky130_ef_sc_hd__decap_12
XFILLER_33_169 VPWR VGND VPWR VGND sky130_ef_sc_hd__decap_12
XFILLER_33_125 VPWR VGND VPWR VGND sky130_ef_sc_hd__decap_12
XFILLER_18_100 VGND VGND VPWR VPWR sky130_fd_sc_hd__decap_3
XFILLER_18_9 VGND VGND VPWR VPWR sky130_fd_sc_hd__fill_1
X_408_ _111_ _131_ _130_ VGND VGND VPWR VPWR next_state\[0\] sky130_fd_sc_hd__or3b_1
XPHY_EDGE_ROW_22_Left_60 VGND VGND VPWR VPWR sky130_fd_sc_hd__decap_3
X_690_ CLK2_counter\[24\] _325_ VGND VGND VPWR VPWR _326_ sky130_fd_sc_hd__xnor2_1
XFILLER_15_169 VGND VGND VPWR VPWR sky130_fd_sc_hd__decap_6
XFILLER_15_147 VGND VGND VPWR VPWR sky130_fd_sc_hd__fill_1
XTAP_TAPCELL_ROW_31_189 VGND VPWR sky130_fd_sc_hd__tapvpwrvgnd_1
XTAP_TAPCELL_ROW_22_156 VGND VPWR sky130_fd_sc_hd__tapvpwrvgnd_1
X_811_ clknet_3_4__leaf_CLK _076_ net71 VGND VGND VPWR VPWR password\[7\] sky130_fd_sc_hd__dfstp_1
X_673_ net51 _313_ _314_ VGND VGND VPWR VPWR _050_ sky130_fd_sc_hd__and3_1
X_742_ clknet_3_3__leaf_CLK _039_ net74 VGND VGND VPWR VPWR CLK2_counter\[7\] sky130_fd_sc_hd__dfrtp_1
XFILLER_14_3 VPWR VGND VPWR VGND sky130_ef_sc_hd__decap_12
XFILLER_7_154 VGND VGND VPWR VPWR sky130_fd_sc_hd__fill_1
XFILLER_26_209 VGND VGND VPWR VPWR sky130_fd_sc_hd__decap_8
XFILLER_27_57 VPWR VGND VPWR VGND sky130_ef_sc_hd__decap_12
XFILLER_8_70 VPWR VGND VPWR VGND sky130_ef_sc_hd__decap_12
X_725_ net31 _348_ VGND VGND VPWR VPWR _068_ sky130_fd_sc_hd__xnor2_1
X_656_ CLK2_counter\[13\] CLK2_counter\[12\] CLK2_counter\[11\] _296_ VGND VGND VPWR
+ VPWR _303_ sky130_fd_sc_hd__and4_1
XTAP_TAPCELL_ROW_10_115 VGND VPWR sky130_fd_sc_hd__tapvpwrvgnd_1
X_587_ _242_ _250_ _261_ _264_ VGND VGND VPWR VPWR net24 sky130_fd_sc_hd__o211a_1
Xfanout49 net50 VGND VGND VPWR VPWR net49 sky130_fd_sc_hd__clkbuf_2
XTAP_TAPCELL_ROW_4_93 VGND VPWR sky130_fd_sc_hd__tapvpwrvgnd_1
X_372_ CLK2_counter\[23\] CLK2_counter\[22\] CLK2_counter\[21\] CLK2_counter\[20\]
+ VGND VGND VPWR VPWR _096_ sky130_fd_sc_hd__or4_1
X_441_ CLK_counter\[29\] CLK_counter\[28\] CLK_counter\[31\] CLK_counter\[30\] VGND
+ VGND VPWR VPWR _161_ sky130_fd_sc_hd__or4_1
X_510_ CLK_counter\[20\] _208_ VGND VGND VPWR VPWR _210_ sky130_fd_sc_hd__and2_1
XFILLER_13_37 VGND VGND VPWR VPWR sky130_fd_sc_hd__decap_8
XFILLER_1_105 VGND VGND VPWR VPWR sky130_fd_sc_hd__decap_6
X_708_ _081_ _336_ _338_ VGND VGND VPWR VPWR _061_ sky130_fd_sc_hd__a21oi_1
X_639_ _291_ net52 _290_ VGND VGND VPWR VPWR _039_ sky130_fd_sc_hd__and3b_1
XFILLER_0_160 VGND VGND VPWR VPWR sky130_fd_sc_hd__decap_4
XFILLER_6_219 VGND VGND VPWR VPWR sky130_fd_sc_hd__fill_2
X_355_ net87 VGND VGND VPWR VPWR _081_ sky130_fd_sc_hd__inv_2
XTAP_TAPCELL_ROW_1_83 VGND VPWR sky130_fd_sc_hd__tapvpwrvgnd_1
X_424_ _140_ _145_ VGND VGND VPWR VPWR _146_ sky130_fd_sc_hd__nand2_1
XFILLER_36_189 VGND VGND VPWR VPWR sky130_fd_sc_hd__decap_6
XFILLER_10_27 VGND VGND VPWR VPWR sky130_fd_sc_hd__fill_1
Xinput6 SW[0] VGND VGND VPWR VPWR net6 sky130_fd_sc_hd__buf_1
XFILLER_35_57 VPWR VGND VPWR VGND sky130_ef_sc_hd__decap_12
XPHY_EDGE_ROW_23_Right_23 VGND VGND VPWR VPWR sky130_fd_sc_hd__decap_3
XFILLER_18_123 VGND VGND VPWR VPWR sky130_fd_sc_hd__decap_4
XPHY_EDGE_ROW_14_Right_14 VGND VGND VPWR VPWR sky130_fd_sc_hd__decap_3
XFILLER_33_137 VPWR VGND VPWR VGND sky130_ef_sc_hd__decap_12
XPHY_EDGE_ROW_32_Right_32 VGND VGND VPWR VPWR sky130_fd_sc_hd__decap_3
X_407_ _110_ _124_ state\[0\] net58 VGND VGND VPWR VPWR _131_ sky130_fd_sc_hd__a2bb2o_1
XTAP_TAPCELL_ROW_34_198 VGND VPWR sky130_fd_sc_hd__tapvpwrvgnd_1
Xmax_cap57 _122_ VGND VGND VPWR VPWR net57 sky130_fd_sc_hd__buf_1
XTAP_TAPCELL_ROW_22_157 VGND VPWR sky130_fd_sc_hd__tapvpwrvgnd_1
X_672_ CLK2_counter\[18\] _312_ VGND VGND VPWR VPWR _314_ sky130_fd_sc_hd__nand2_1
X_741_ clknet_3_3__leaf_CLK _038_ net69 VGND VGND VPWR VPWR CLK2_counter\[6\] sky130_fd_sc_hd__dfrtp_1
X_810_ clknet_3_4__leaf_CLK _075_ net71 VGND VGND VPWR VPWR password\[6\] sky130_fd_sc_hd__dfrtp_1
XFILLER_7_111 VGND VGND VPWR VPWR sky130_fd_sc_hd__fill_1
XFILLER_7_122 VGND VGND VPWR VPWR sky130_fd_sc_hd__decap_4
XTAP_TAPCELL_ROW_36_205 VGND VPWR sky130_fd_sc_hd__tapvpwrvgnd_1
XPHY_EDGE_ROW_4_Right_4 VGND VGND VPWR VPWR sky130_fd_sc_hd__decap_3
XFILLER_8_82 VGND VGND VPWR VPWR sky130_fd_sc_hd__fill_2
XFILLER_27_69 VGND VGND VPWR VPWR sky130_fd_sc_hd__fill_2
XFILLER_25_210 VGND VGND VPWR VPWR sky130_fd_sc_hd__decap_6
X_724_ _347_ _348_ VGND VGND VPWR VPWR _067_ sky130_fd_sc_hd__nor2_1
XTAP_TAPCELL_ROW_10_116 VGND VPWR sky130_fd_sc_hd__tapvpwrvgnd_1
XFILLER_4_29 VPWR VGND VPWR VGND sky130_ef_sc_hd__decap_12
X_655_ CLK2_counter\[13\] _301_ VGND VGND VPWR VPWR _302_ sky130_fd_sc_hd__or2_1
XTAP_TAPCELL_ROW_4_94 VGND VPWR sky130_fd_sc_hd__tapvpwrvgnd_1
X_586_ _123_ _262_ _263_ _243_ VGND VGND VPWR VPWR _264_ sky130_fd_sc_hd__o211a_1
X_440_ CLK_counter\[25\] CLK_counter\[24\] CLK_counter\[27\] CLK_counter\[26\] VGND
+ VGND VPWR VPWR _160_ sky130_fd_sc_hd__or4_1
X_371_ CLK2_counter\[31\] CLK2_counter\[30\] CLK2_counter\[29\] CLK2_counter\[28\]
+ VGND VGND VPWR VPWR _095_ sky130_fd_sc_hd__or4_1
XFILLER_1_128 VGND VGND VPWR VPWR sky130_fd_sc_hd__decap_3
X_707_ _334_ _337_ net51 VGND VGND VPWR VPWR _338_ sky130_fd_sc_hd__a21bo_1
X_638_ CLK2_counter\[7\] _289_ VGND VGND VPWR VPWR _291_ sky130_fd_sc_hd__and2_1
X_569_ _241_ _249_ VGND VGND VPWR VPWR _250_ sky130_fd_sc_hd__nand2_1
XFILLER_24_37 VGND VGND VPWR VPWR sky130_fd_sc_hd__decap_3
XFILLER_24_15 VPWR VGND VPWR VGND sky130_ef_sc_hd__decap_12
X_354_ CLK2_counter\[9\] VGND VGND VPWR VPWR _080_ sky130_fd_sc_hd__inv_2
X_423_ _141_ _142_ _143_ _144_ VGND VGND VPWR VPWR _145_ sky130_fd_sc_hd__and4_1
Xinput7 SW[1] VGND VGND VPWR VPWR net7 sky130_fd_sc_hd__buf_1
XTAP_TAPCELL_ROW_1_84 VGND VPWR sky130_fd_sc_hd__tapvpwrvgnd_1
XFILLER_35_69 VPWR VGND VPWR VGND sky130_ef_sc_hd__decap_12
XFILLER_4_3 VPWR VGND VPWR VGND sky130_ef_sc_hd__decap_12
XFILLER_37_3 VPWR VGND VPWR VGND sky130_ef_sc_hd__decap_12
XFILLER_33_149 VPWR VGND VPWR VGND sky130_ef_sc_hd__decap_12
XFILLER_26_190 VGND VGND VPWR VPWR sky130_fd_sc_hd__decap_6
X_406_ _126_ _128_ _129_ _123_ VGND VGND VPWR VPWR _130_ sky130_fd_sc_hd__a31o_1
XTAP_TAPCELL_ROW_34_199 VGND VPWR sky130_fd_sc_hd__tapvpwrvgnd_1
XFILLER_24_105 VPWR VGND VPWR VGND sky130_ef_sc_hd__decap_12
XFILLER_32_37 VGND VGND VPWR VPWR sky130_fd_sc_hd__fill_1
XFILLER_32_15 VGND VGND VPWR VPWR sky130_fd_sc_hd__decap_8
XTAP_TAPCELL_ROW_22_158 VGND VPWR sky130_fd_sc_hd__tapvpwrvgnd_1
XFILLER_21_119 VGND VGND VPWR VPWR sky130_fd_sc_hd__fill_1
Xinput10 SW[4] VGND VGND VPWR VPWR net10 sky130_fd_sc_hd__buf_1
X_671_ CLK2_counter\[18\] _312_ VGND VGND VPWR VPWR _313_ sky130_fd_sc_hd__or2_1
X_740_ clknet_3_3__leaf_CLK _037_ net69 VGND VGND VPWR VPWR CLK2_counter\[5\] sky130_fd_sc_hd__dfrtp_1
XTAP_TAPCELL_ROW_13_125 VGND VPWR sky130_fd_sc_hd__tapvpwrvgnd_1
XTAP_TAPCELL_ROW_36_206 VGND VPWR sky130_fd_sc_hd__tapvpwrvgnd_1
XFILLER_22_81 VGND VGND VPWR VPWR sky130_fd_sc_hd__decap_3
XFILLER_7_167 VGND VGND VPWR VPWR sky130_fd_sc_hd__fill_1
XTAP_TAPCELL_ROW_10_117 VGND VPWR sky130_fd_sc_hd__tapvpwrvgnd_1
XFILLER_31_203 VPWR VGND VPWR VGND sky130_ef_sc_hd__decap_12
X_723_ attempt_count\[3\] net61 _345_ VGND VGND VPWR VPWR _348_ sky130_fd_sc_hd__and3_1
X_654_ _301_ net52 _300_ VGND VGND VPWR VPWR _044_ sky130_fd_sc_hd__and3b_1
XFILLER_17_81 VPWR VGND VPWR VGND sky130_ef_sc_hd__decap_12
XTAP_TAPCELL_ROW_4_95 VGND VPWR sky130_fd_sc_hd__tapvpwrvgnd_1
X_585_ net63 _238_ _247_ _244_ _079_ VGND VGND VPWR VPWR _263_ sky130_fd_sc_hd__o32a_1
X_370_ CLK2_counter\[27\] CLK2_counter\[26\] CLK2_counter\[25\] CLK2_counter\[24\]
+ VGND VGND VPWR VPWR _094_ sky130_fd_sc_hd__or4_1
X_706_ CLK2_counter\[29\] CLK2_counter\[28\] VGND VGND VPWR VPWR _337_ sky130_fd_sc_hd__and2_1
X_637_ CLK2_counter\[7\] _289_ VGND VGND VPWR VPWR _290_ sky130_fd_sc_hd__or2_1
XFILLER_0_195 VGND VGND VPWR VPWR sky130_fd_sc_hd__fill_1
XFILLER_24_27 VGND VGND VPWR VPWR sky130_fd_sc_hd__fill_1
X_499_ net78 _201_ _202_ VGND VGND VPWR VPWR _007_ sky130_fd_sc_hd__a21oi_1
XFILLER_5_40 VGND VGND VPWR VPWR sky130_fd_sc_hd__decap_4
XFILLER_5_62 VPWR VGND VPWR VGND sky130_ef_sc_hd__decap_12
X_568_ net64 _079_ VGND VGND VPWR VPWR _249_ sky130_fd_sc_hd__nand2_1
X_353_ CLK2_counter\[0\] VGND VGND VPWR VPWR _079_ sky130_fd_sc_hd__inv_2
X_422_ net8 net10 net12 net6 VGND VGND VPWR VPWR _144_ sky130_fd_sc_hd__a2bb2o_1
XTAP_TAPCELL_ROW_1_85 VGND VPWR sky130_fd_sc_hd__tapvpwrvgnd_1
Xinput8 SW[2] VGND VGND VPWR VPWR net8 sky130_fd_sc_hd__buf_1
X_405_ _082_ net2 VGND VGND VPWR VPWR _129_ sky130_fd_sc_hd__nand2_1
Xclkbuf_3_1__f_CLK clknet_0_CLK VGND VGND VPWR VPWR clknet_3_1__leaf_CLK sky130_fd_sc_hd__clkbuf_16
XFILLER_32_194 VGND VGND VPWR VPWR sky130_fd_sc_hd__fill_2
XFILLER_24_139 VGND VGND VPWR VPWR sky130_fd_sc_hd__fill_1
XFILLER_24_117 VPWR VGND VPWR VGND sky130_ef_sc_hd__decap_12
XTAP_TAPCELL_ROW_25_167 VGND VPWR sky130_fd_sc_hd__tapvpwrvgnd_1
XFILLER_15_117 VGND VGND VPWR VPWR sky130_fd_sc_hd__decap_3
XPHY_EDGE_ROW_26_Left_64 VGND VGND VPWR VPWR sky130_fd_sc_hd__decap_3
XFILLER_14_183 VPWR VGND VPWR VGND sky130_ef_sc_hd__decap_12
XPHY_EDGE_ROW_10_Left_48 VGND VGND VPWR VPWR sky130_fd_sc_hd__decap_3
Xinput11 SW[5] VGND VGND VPWR VPWR net11 sky130_fd_sc_hd__buf_1
X_670_ _312_ net51 _310_ VGND VGND VPWR VPWR _049_ sky130_fd_sc_hd__and3b_1
XTAP_TAPCELL_ROW_22_159 VGND VPWR sky130_fd_sc_hd__tapvpwrvgnd_1
XFILLER_20_197 VPWR VGND VPWR VGND sky130_ef_sc_hd__decap_12
XTAP_TAPCELL_ROW_36_207 VGND VPWR sky130_fd_sc_hd__tapvpwrvgnd_1
X_799_ clknet_3_2__leaf_CLK _019_ net70 VGND VGND VPWR VPWR CLK_counter\[27\] sky130_fd_sc_hd__dfrtp_1
XTAP_TAPCELL_ROW_13_126 VGND VPWR sky130_fd_sc_hd__tapvpwrvgnd_1
XFILLER_11_164 VGND VGND VPWR VPWR sky130_fd_sc_hd__decap_4
XFILLER_7_113 VGND VGND VPWR VPWR sky130_fd_sc_hd__decap_3
XFILLER_7_146 VGND VGND VPWR VPWR sky130_fd_sc_hd__decap_8
XFILLER_8_51 VPWR VGND VPWR VGND sky130_ef_sc_hd__decap_12
XFILLER_27_38 VPWR VGND VPWR VGND sky130_ef_sc_hd__decap_12
XFILLER_31_215 VGND VGND VPWR VPWR sky130_fd_sc_hd__fill_2
X_722_ net61 _345_ attempt_count\[3\] VGND VGND VPWR VPWR _347_ sky130_fd_sc_hd__a21oi_1
X_653_ CLK2_counter\[12\] CLK2_counter\[11\] _296_ VGND VGND VPWR VPWR _301_ sky130_fd_sc_hd__and3_1
XFILLER_17_93 VGND VGND VPWR VPWR sky130_fd_sc_hd__decap_6
XFILLER_4_127 VPWR VGND VPWR VGND sky130_ef_sc_hd__decap_12
XTAP_TAPCELL_ROW_4_96 VGND VPWR sky130_fd_sc_hd__tapvpwrvgnd_1
X_584_ _106_ _235_ VGND VGND VPWR VPWR _262_ sky130_fd_sc_hd__nor2_1
XFILLER_12_3 VGND VGND VPWR VPWR sky130_fd_sc_hd__decap_8
XPHY_EDGE_ROW_13_Left_51 VGND VGND VPWR VPWR sky130_fd_sc_hd__decap_3
XFILLER_0_174 VGND VGND VPWR VPWR sky130_fd_sc_hd__decap_4
XFILLER_0_141 VGND VGND VPWR VPWR sky130_fd_sc_hd__fill_2
X_705_ net49 _335_ _336_ VGND VGND VPWR VPWR _060_ sky130_fd_sc_hd__and3_1
X_636_ _288_ _289_ VGND VGND VPWR VPWR _038_ sky130_fd_sc_hd__nor2_1
X_498_ CLK_counter\[16\] _201_ net50 VGND VGND VPWR VPWR _202_ sky130_fd_sc_hd__o21ai_1
X_567_ _105_ _246_ _248_ _237_ _245_ VGND VGND VPWR VPWR net28 sky130_fd_sc_hd__o221a_1
XFILLER_5_52 VGND VGND VPWR VPWR sky130_fd_sc_hd__decap_4
XFILLER_5_74 VGND VGND VPWR VPWR sky130_fd_sc_hd__decap_8
XFILLER_5_85 VGND VGND VPWR VPWR sky130_fd_sc_hd__decap_8
X_421_ net9 net11 _087_ _083_ VGND VGND VPWR VPWR _143_ sky130_fd_sc_hd__a22o_1
XFILLER_14_83 VGND VGND VPWR VPWR sky130_fd_sc_hd__fill_1
X_352_ net62 VGND VGND VPWR VPWR _078_ sky130_fd_sc_hd__inv_2
Xinput9 SW[3] VGND VGND VPWR VPWR net9 sky130_fd_sc_hd__buf_1
X_619_ _171_ _278_ _079_ VGND VGND VPWR VPWR _032_ sky130_fd_sc_hd__mux2_1
XFILLER_35_181 VPWR VGND VPWR VGND sky130_ef_sc_hd__decap_12
XFILLER_18_148 VGND VGND VPWR VPWR sky130_fd_sc_hd__fill_2
X_404_ net1 _121_ VGND VGND VPWR VPWR _128_ sky130_fd_sc_hd__nand2_1
XFILLER_24_129 VGND VGND VPWR VPWR sky130_fd_sc_hd__decap_4
XPHY_EDGE_ROW_10_Right_10 VGND VGND VPWR VPWR sky130_fd_sc_hd__decap_3
XTAP_TAPCELL_ROW_25_168 VGND VPWR sky130_fd_sc_hd__tapvpwrvgnd_1
XFILLER_11_51 VGND VGND VPWR VPWR sky130_fd_sc_hd__decap_4
XTAP_TAPCELL_ROW_16_135 VGND VPWR sky130_fd_sc_hd__tapvpwrvgnd_1
XFILLER_14_195 VGND VGND VPWR VPWR sky130_fd_sc_hd__fill_1
Xinput12 SW[6] VGND VGND VPWR VPWR net12 sky130_fd_sc_hd__buf_1
XFILLER_20_121 VPWR VGND VPWR VGND sky130_ef_sc_hd__decap_12
XTAP_TAPCELL_ROW_36_208 VGND VPWR sky130_fd_sc_hd__tapvpwrvgnd_1
X_798_ clknet_3_2__leaf_CLK _018_ net69 VGND VGND VPWR VPWR CLK_counter\[26\] sky130_fd_sc_hd__dfrtp_1
XFILLER_22_94 VPWR VGND VPWR VGND sky130_ef_sc_hd__decap_12
XTAP_TAPCELL_ROW_13_127 VGND VPWR sky130_fd_sc_hd__tapvpwrvgnd_1
XFILLER_7_136 VGND VGND VPWR VPWR sky130_fd_sc_hd__decap_6
XFILLER_8_63 VGND VGND VPWR VPWR sky130_fd_sc_hd__fill_2
XFILLER_8_85 VGND VGND VPWR VPWR sky130_fd_sc_hd__decap_4
X_652_ CLK2_counter\[12\] _299_ VGND VGND VPWR VPWR _300_ sky130_fd_sc_hd__or2_1
X_721_ net61 _345_ VGND VGND VPWR VPWR _066_ sky130_fd_sc_hd__xor2_1
X_583_ _153_ _260_ _155_ VGND VGND VPWR VPWR _261_ sky130_fd_sc_hd__o21ai_1
XFILLER_4_139 VGND VGND VPWR VPWR sky130_fd_sc_hd__fill_1
Xhold1 CLK_counter\[16\] VGND VGND VPWR VPWR net78 sky130_fd_sc_hd__dlygate4sd3_1
XPHY_EDGE_ROW_8_Right_8 VGND VGND VPWR VPWR sky130_fd_sc_hd__decap_3
X_704_ CLK2_counter\[28\] _334_ VGND VGND VPWR VPWR _336_ sky130_fd_sc_hd__nand2_1
X_635_ CLK2_counter\[6\] CLK2_counter\[4\] CLK2_counter\[5\] _283_ VGND VGND VPWR
+ VPWR _289_ sky130_fd_sc_hd__and4_1
X_497_ _201_ _171_ _200_ VGND VGND VPWR VPWR _006_ sky130_fd_sc_hd__and3b_1
XFILLER_0_197 VPWR VGND VPWR VGND sky130_ef_sc_hd__decap_12
XFILLER_0_153 VGND VGND VPWR VPWR sky130_fd_sc_hd__decap_4
X_566_ _078_ _106_ _247_ VGND VGND VPWR VPWR _248_ sky130_fd_sc_hd__o21bai_1
XFILLER_24_29 VGND VGND VPWR VPWR sky130_fd_sc_hd__decap_8
XFILLER_30_83 VGND VGND VPWR VPWR sky130_fd_sc_hd__fill_1
X_351_ CLK2_counter\[3\] VGND VGND VPWR VPWR _077_ sky130_fd_sc_hd__inv_2
X_420_ net6 net12 net10 net8 VGND VGND VPWR VPWR _142_ sky130_fd_sc_hd__a2bb2o_1
XFILLER_27_127 VGND VGND VPWR VPWR sky130_fd_sc_hd__decap_8
X_549_ net64 _234_ _231_ VGND VGND VPWR VPWR _236_ sky130_fd_sc_hd__o21a_1
X_618_ net47 _170_ VGND VGND VPWR VPWR _278_ sky130_fd_sc_hd__and2_1
XFILLER_35_193 VPWR VGND VPWR VGND sky130_ef_sc_hd__decap_12
XTAP_TAPCELL_ROW_28_177 VGND VPWR sky130_fd_sc_hd__tapvpwrvgnd_1
X_403_ net60 net58 _123_ _126_ VGND VGND VPWR VPWR _127_ sky130_fd_sc_hd__o2bb2a_1
XFILLER_32_141 VGND VGND VPWR VPWR sky130_fd_sc_hd__decap_6
XFILLER_17_193 VGND VGND VPWR VPWR sky130_fd_sc_hd__decap_8
XFILLER_2_98 VGND VGND VPWR VPWR sky130_fd_sc_hd__fill_1
XTAP_TAPCELL_ROW_25_169 VGND VPWR sky130_fd_sc_hd__tapvpwrvgnd_1
XTAP_TAPCELL_ROW_16_136 VGND VPWR sky130_fd_sc_hd__tapvpwrvgnd_1
Xinput13 SW[7] VGND VGND VPWR VPWR net13 sky130_fd_sc_hd__buf_1
XTAP_TAPCELL_ROW_7_104 VGND VPWR sky130_fd_sc_hd__tapvpwrvgnd_1
XFILLER_22_73 VGND VGND VPWR VPWR sky130_fd_sc_hd__decap_8
XFILLER_7_159 VGND VGND VPWR VPWR sky130_fd_sc_hd__decap_8
X_797_ clknet_3_2__leaf_CLK _017_ net70 VGND VGND VPWR VPWR CLK_counter\[25\] sky130_fd_sc_hd__dfrtp_1
XFILLER_8_20 VGND VGND VPWR VPWR sky130_fd_sc_hd__decap_8
X_651_ _298_ _299_ net53 VGND VGND VPWR VPWR _043_ sky130_fd_sc_hd__nor3b_1
X_720_ _345_ _346_ VGND VGND VPWR VPWR _065_ sky130_fd_sc_hd__nor2_1
X_582_ CLK2_counter\[10\] _100_ VGND VGND VPWR VPWR _260_ sky130_fd_sc_hd__nor2_1
Xhold2 CLK_counter\[21\] VGND VGND VPWR VPWR net79 sky130_fd_sc_hd__dlygate4sd3_1
Xclkbuf_3_7__f_CLK clknet_0_CLK VGND VGND VPWR VPWR clknet_3_7__leaf_CLK sky130_fd_sc_hd__clkbuf_16
XFILLER_13_217 VGND VGND VPWR VPWR sky130_fd_sc_hd__decap_4
X_703_ CLK2_counter\[28\] _334_ VGND VGND VPWR VPWR _335_ sky130_fd_sc_hd__or2_1
X_634_ CLK2_counter\[6\] _287_ net50 VGND VGND VPWR VPWR _288_ sky130_fd_sc_hd__o21ai_1
X_496_ CLK_counter\[13\] CLK_counter\[12\] _165_ _192_ VGND VGND VPWR VPWR _201_ sky130_fd_sc_hd__and4_1
X_565_ state\[2\] _124_ VGND VGND VPWR VPWR _247_ sky130_fd_sc_hd__or2_1
XFILLER_10_209 VGND VGND VPWR VPWR sky130_fd_sc_hd__fill_1
XFILLER_5_98 VGND VGND VPWR VPWR sky130_fd_sc_hd__decap_8
X_350_ attempt_count\[4\] VGND VGND VPWR VPWR net31 sky130_fd_sc_hd__inv_2
XFILLER_36_139 VGND VGND VPWR VPWR sky130_fd_sc_hd__fill_1
X_617_ attempt_count\[3\] _277_ VGND VGND VPWR VPWR net37 sky130_fd_sc_hd__nor2_1
XFILLER_19_19 VPWR VGND VPWR VGND sky130_ef_sc_hd__decap_12
X_479_ _189_ _171_ _188_ VGND VGND VPWR VPWR _031_ sky130_fd_sc_hd__and3b_1
X_548_ _234_ VGND VGND VPWR VPWR _235_ sky130_fd_sc_hd__inv_2
XFILLER_35_161 VGND VGND VPWR VPWR sky130_fd_sc_hd__decap_6
XFILLER_35_18 VPWR VGND VPWR VGND sky130_ef_sc_hd__decap_12
XFILLER_32_131 VGND VGND VPWR VPWR sky130_fd_sc_hd__fill_1
XFILLER_32_120 VGND VGND VPWR VPWR sky130_fd_sc_hd__decap_4
XTAP_TAPCELL_ROW_28_178 VGND VPWR sky130_fd_sc_hd__tapvpwrvgnd_1
XFILLER_26_161 VGND VGND VPWR VPWR sky130_fd_sc_hd__decap_8
XFILLER_25_40 VGND VGND VPWR VPWR sky130_fd_sc_hd__decap_8
Xclkbuf_0_CLK CLK VGND VGND VPWR VPWR clknet_0_CLK sky130_fd_sc_hd__clkbuf_16
X_402_ net31 attempt_count\[0\] attempt_count\[3\] _125_ VGND VGND VPWR VPWR _126_
+ sky130_fd_sc_hd__or4_1
XFILLER_32_197 VPWR VGND VPWR VGND sky130_ef_sc_hd__decap_12
XFILLER_36_83 VGND VGND VPWR VPWR sky130_fd_sc_hd__fill_1
XTAP_TAPCELL_ROW_16_137 VGND VPWR sky130_fd_sc_hd__tapvpwrvgnd_1
XTAP_TAPCELL_ROW_30_184 VGND VPWR sky130_fd_sc_hd__tapvpwrvgnd_1
XFILLER_28_3 VPWR VGND VPWR VGND sky130_ef_sc_hd__decap_12
XFILLER_20_156 VPWR VGND VPWR VGND sky130_ef_sc_hd__decap_12
XTAP_TAPCELL_ROW_7_105 VGND VPWR sky130_fd_sc_hd__tapvpwrvgnd_1
X_796_ clknet_3_2__leaf_CLK _016_ net68 VGND VGND VPWR VPWR CLK_counter\[24\] sky130_fd_sc_hd__dfrtp_1
XFILLER_8_98 VGND VGND VPWR VPWR sky130_fd_sc_hd__decap_3
X_650_ CLK2_counter\[11\] _296_ VGND VGND VPWR VPWR _299_ sky130_fd_sc_hd__and2_1
Xhold3 CLK_counter\[25\] VGND VGND VPWR VPWR net80 sky130_fd_sc_hd__dlygate4sd3_1
XFILLER_3_163 VGND VGND VPWR VPWR sky130_fd_sc_hd__decap_4
X_581_ _251_ _258_ _259_ VGND VGND VPWR VPWR net25 sky130_fd_sc_hd__and3_1
X_779_ clknet_3_0__leaf_CLK _029_ net65 VGND VGND VPWR VPWR CLK_counter\[7\] sky130_fd_sc_hd__dfrtp_1
XFILLER_13_207 VGND VGND VPWR VPWR sky130_fd_sc_hd__decap_4
X_702_ _334_ net51 _332_ VGND VGND VPWR VPWR _059_ sky130_fd_sc_hd__and3b_1
X_633_ _287_ net50 _286_ VGND VGND VPWR VPWR _037_ sky130_fd_sc_hd__and3b_1
X_495_ CLK_counter\[14\] _196_ CLK_counter\[15\] VGND VGND VPWR VPWR _200_ sky130_fd_sc_hd__a21o_1
XFILLER_0_188 VGND VGND VPWR VPWR sky130_fd_sc_hd__decap_4
XFILLER_0_133 VGND VGND VPWR VPWR sky130_fd_sc_hd__decap_3
X_564_ net62 CLK2_counter\[1\] _123_ VGND VGND VPWR VPWR _246_ sky130_fd_sc_hd__a21o_1
XPHY_EDGE_ROW_17_Left_55 VGND VGND VPWR VPWR sky130_fd_sc_hd__decap_3
XFILLER_5_44 VGND VGND VPWR VPWR sky130_fd_sc_hd__fill_1
XFILLER_30_85 VGND VGND VPWR VPWR sky130_fd_sc_hd__decap_8
X_616_ _125_ _273_ VGND VGND VPWR VPWR net36 sky130_fd_sc_hd__nor2_1
X_478_ _166_ _184_ VGND VGND VPWR VPWR _189_ sky130_fd_sc_hd__and2_1
X_547_ _078_ CLK2_counter\[0\] VGND VGND VPWR VPWR _234_ sky130_fd_sc_hd__nand2_1
XTAP_TAPCELL_ROW_28_179 VGND VPWR sky130_fd_sc_hd__tapvpwrvgnd_1
X_401_ attempt_count\[1\] net61 VGND VGND VPWR VPWR _125_ sky130_fd_sc_hd__or2_1
XTAP_TAPCELL_ROW_19_146 VGND VPWR sky130_fd_sc_hd__tapvpwrvgnd_1
XFILLER_17_173 VGND VGND VPWR VPWR sky130_fd_sc_hd__decap_8
XFILLER_23_176 VGND VGND VPWR VPWR sky130_fd_sc_hd__decap_3
XFILLER_23_154 VGND VGND VPWR VPWR sky130_fd_sc_hd__decap_8
XFILLER_23_143 VGND VGND VPWR VPWR sky130_fd_sc_hd__decap_4
XTAP_TAPCELL_ROW_16_138 VGND VPWR sky130_fd_sc_hd__tapvpwrvgnd_1
XTAP_TAPCELL_ROW_30_185 VGND VPWR sky130_fd_sc_hd__tapvpwrvgnd_1
XFILLER_20_168 VPWR VGND VPWR VGND sky130_ef_sc_hd__decap_12
XFILLER_9_180 VGND VGND VPWR VPWR sky130_fd_sc_hd__decap_3
XTAP_TAPCELL_ROW_7_106 VGND VPWR sky130_fd_sc_hd__tapvpwrvgnd_1
X_795_ clknet_3_2__leaf_CLK _015_ net68 VGND VGND VPWR VPWR CLK_counter\[23\] sky130_fd_sc_hd__dfrtp_1
XPHY_EDGE_ROW_5_Left_43 VGND VGND VPWR VPWR sky130_fd_sc_hd__decap_3
XFILLER_8_11 VGND VGND VPWR VPWR sky130_fd_sc_hd__fill_2
XFILLER_25_216 VGND VGND VPWR VPWR sky130_fd_sc_hd__fill_1
XPHY_EDGE_ROW_31_Left_69 VGND VGND VPWR VPWR sky130_fd_sc_hd__decap_3
XFILLER_17_53 VGND VGND VPWR VPWR sky130_fd_sc_hd__decap_3
X_580_ CLK2_counter\[9\] _134_ _153_ _235_ _254_ VGND VGND VPWR VPWR _259_ sky130_fd_sc_hd__o32a_1
Xhold4 password\[5\] VGND VGND VPWR VPWR net81 sky130_fd_sc_hd__dlygate4sd3_1
X_778_ clknet_3_0__leaf_CLK _028_ net65 VGND VGND VPWR VPWR CLK_counter\[6\] sky130_fd_sc_hd__dfrtp_1
X_701_ CLK2_counter\[23\] _323_ _328_ _333_ VGND VGND VPWR VPWR _334_ sky130_fd_sc_hd__and4_2
XFILLER_28_85 VPWR VGND VPWR VGND sky130_ef_sc_hd__decap_12
XPHY_EDGE_ROW_26_Right_26 VGND VGND VPWR VPWR sky130_fd_sc_hd__decap_3
X_632_ CLK2_counter\[4\] CLK2_counter\[5\] _283_ VGND VGND VPWR VPWR _287_ sky130_fd_sc_hd__and3_1
XPHY_EDGE_ROW_17_Right_17 VGND VGND VPWR VPWR sky130_fd_sc_hd__decap_3
XFILLER_0_167 VGND VGND VPWR VPWR sky130_fd_sc_hd__fill_1
X_563_ _106_ _242_ _244_ _238_ _243_ VGND VGND VPWR VPWR _245_ sky130_fd_sc_hd__o221a_1
XPHY_EDGE_ROW_35_Right_35 VGND VGND VPWR VPWR sky130_fd_sc_hd__decap_3
X_494_ _171_ _198_ _199_ VGND VGND VPWR VPWR _005_ sky130_fd_sc_hd__and3_1
XPHY_EDGE_ROW_34_Left_72 VGND VGND VPWR VPWR sky130_fd_sc_hd__decap_3
XFILLER_30_75 VGND VGND VPWR VPWR sky130_fd_sc_hd__decap_8
X_615_ _274_ net34 VGND VGND VPWR VPWR net35 sky130_fd_sc_hd__and2_1
X_477_ CLK_counter\[8\] _184_ CLK_counter\[9\] VGND VGND VPWR VPWR _188_ sky130_fd_sc_hd__a21o_1
X_546_ _231_ _232_ _233_ VGND VGND VPWR VPWR net19 sky130_fd_sc_hd__a21o_1
X_400_ state\[1\] net60 VGND VGND VPWR VPWR _124_ sky130_fd_sc_hd__nand2b_1
XFILLER_32_166 VGND VGND VPWR VPWR sky130_fd_sc_hd__fill_2
X_529_ CLK_counter\[27\] CLK_counter\[26\] _218_ VGND VGND VPWR VPWR _222_ sky130_fd_sc_hd__and3_1
XTAP_TAPCELL_ROW_19_147 VGND VPWR sky130_fd_sc_hd__tapvpwrvgnd_1
XFILLER_23_199 VPWR VGND VPWR VGND sky130_ef_sc_hd__decap_12
XFILLER_23_133 VGND VGND VPWR VPWR sky130_fd_sc_hd__fill_2
XFILLER_11_55 VGND VGND VPWR VPWR sky130_fd_sc_hd__fill_1
XFILLER_36_85 VPWR VGND VPWR VGND sky130_ef_sc_hd__decap_12
XFILLER_36_41 VPWR VGND VPWR VGND sky130_ef_sc_hd__decap_12
XFILLER_35_6 VPWR VGND VPWR VGND sky130_ef_sc_hd__decap_12
XFILLER_14_144 VPWR VGND VPWR VGND sky130_ef_sc_hd__decap_12
XTAP_TAPCELL_ROW_30_186 VGND VPWR sky130_fd_sc_hd__tapvpwrvgnd_1
X_794_ clknet_3_2__leaf_CLK _014_ net68 VGND VGND VPWR VPWR CLK_counter\[22\] sky130_fd_sc_hd__dfrtp_1
XTAP_TAPCELL_ROW_21_153 VGND VPWR sky130_fd_sc_hd__tapvpwrvgnd_1
XFILLER_0_3 VPWR VGND VPWR VGND sky130_ef_sc_hd__decap_12
XFILLER_33_3 VPWR VGND VPWR VGND sky130_ef_sc_hd__decap_12
XFILLER_6_184 VGND VGND VPWR VPWR sky130_fd_sc_hd__decap_4
XFILLER_33_75 VPWR VGND VPWR VGND sky130_ef_sc_hd__decap_12
XFILLER_16_206 VGND VGND VPWR VPWR sky130_fd_sc_hd__fill_1
Xhold5 CLK_counter\[23\] VGND VGND VPWR VPWR net82 sky130_fd_sc_hd__dlygate4sd3_1
XFILLER_22_209 VGND VGND VPWR VPWR sky130_fd_sc_hd__decap_8
X_777_ clknet_3_0__leaf_CLK _027_ net65 VGND VGND VPWR VPWR CLK_counter\[5\] sky130_fd_sc_hd__dfrtp_1
X_700_ CLK2_counter\[27\] CLK2_counter\[26\] VGND VGND VPWR VPWR _333_ sky130_fd_sc_hd__and2_1
XFILLER_0_146 VGND VGND VPWR VPWR sky130_fd_sc_hd__decap_4
XFILLER_0_113 VGND VGND VPWR VPWR sky130_fd_sc_hd__fill_2
XFILLER_28_97 VGND VGND VPWR VPWR sky130_fd_sc_hd__decap_4
X_631_ CLK2_counter\[5\] _285_ VGND VGND VPWR VPWR _286_ sky130_fd_sc_hd__or2_1
X_493_ CLK_counter\[14\] _196_ VGND VGND VPWR VPWR _199_ sky130_fd_sc_hd__or2_1
X_562_ net63 _124_ state\[2\] VGND VGND VPWR VPWR _244_ sky130_fd_sc_hd__or3b_2
XFILLER_36_109 VPWR VGND VPWR VGND sky130_ef_sc_hd__decap_12
X_614_ net61 _273_ VGND VGND VPWR VPWR net34 sky130_fd_sc_hd__nor2_1
X_545_ _080_ _133_ _153_ state\[1\] net60 VGND VGND VPWR VPWR _233_ sky130_fd_sc_hd__a32o_1
X_476_ _171_ _186_ _187_ VGND VGND VPWR VPWR _030_ sky130_fd_sc_hd__and3_1
XFILLER_26_197 VPWR VGND VPWR VGND sky130_ef_sc_hd__decap_12
XFILLER_25_65 VGND VGND VPWR VPWR sky130_fd_sc_hd__fill_1
XFILLER_25_54 VGND VGND VPWR VPWR sky130_fd_sc_hd__fill_2
X_528_ _220_ _221_ VGND VGND VPWR VPWR _018_ sky130_fd_sc_hd__nor2_1
XTAP_TAPCELL_ROW_19_148 VGND VPWR sky130_fd_sc_hd__tapvpwrvgnd_1
X_459_ CLK_counter\[3\] _173_ VGND VGND VPWR VPWR _176_ sky130_fd_sc_hd__or2_1
XTAP_TAPCELL_ROW_33_195 VGND VPWR sky130_fd_sc_hd__tapvpwrvgnd_1
XFILLER_23_101 VGND VGND VPWR VPWR sky130_fd_sc_hd__decap_8
XFILLER_36_97 VPWR VGND VPWR VGND sky130_ef_sc_hd__decap_12
XFILLER_36_53 VPWR VGND VPWR VGND sky130_ef_sc_hd__decap_12
XFILLER_14_156 VPWR VGND VPWR VGND sky130_ef_sc_hd__decap_12
XFILLER_14_112 VPWR VGND VPWR VGND sky130_ef_sc_hd__decap_12
XTAP_TAPCELL_ROW_30_187 VGND VPWR sky130_fd_sc_hd__tapvpwrvgnd_1
XFILLER_20_148 VGND VGND VPWR VPWR sky130_fd_sc_hd__fill_1
X_793_ clknet_3_2__leaf_CLK _013_ net68 VGND VGND VPWR VPWR CLK_counter\[21\] sky130_fd_sc_hd__dfrtp_1
XFILLER_22_11 VGND VGND VPWR VPWR sky130_fd_sc_hd__decap_3
XTAP_TAPCELL_ROW_21_154 VGND VPWR sky130_fd_sc_hd__tapvpwrvgnd_1
XTAP_TAPCELL_ROW_35_202 VGND VPWR sky130_fd_sc_hd__tapvpwrvgnd_1
Xclkbuf_3_2__f_CLK clknet_0_CLK VGND VGND VPWR VPWR clknet_3_2__leaf_CLK sky130_fd_sc_hd__clkbuf_16
XTAP_TAPCELL_ROW_12_121 VGND VPWR sky130_fd_sc_hd__tapvpwrvgnd_1
XFILLER_6_141 VGND VGND VPWR VPWR sky130_fd_sc_hd__fill_2
XFILLER_6_174 VGND VGND VPWR VPWR sky130_fd_sc_hd__fill_1
XFILLER_33_87 VPWR VGND VPWR VGND sky130_ef_sc_hd__decap_12
XFILLER_17_99 VGND VGND VPWR VPWR sky130_fd_sc_hd__fill_1
XFILLER_17_33 VPWR VGND VPWR VGND sky130_ef_sc_hd__decap_12
XFILLER_16_218 VGND VGND VPWR VPWR sky130_fd_sc_hd__decap_3
X_776_ clknet_3_0__leaf_CLK _026_ net65 VGND VGND VPWR VPWR CLK_counter\[4\] sky130_fd_sc_hd__dfrtp_1
XFILLER_3_111 VGND VGND VPWR VPWR sky130_fd_sc_hd__fill_1
XFILLER_3_199 VGND VGND VPWR VPWR sky130_fd_sc_hd__fill_1
Xhold6 password\[6\] VGND VGND VPWR VPWR net83 sky130_fd_sc_hd__dlygate4sd3_1
XFILLER_0_91 VGND VGND VPWR VPWR sky130_fd_sc_hd__decap_3
XPHY_EDGE_ROW_3_Right_3 VGND VGND VPWR VPWR sky130_fd_sc_hd__decap_3
XFILLER_28_76 VGND VGND VPWR VPWR sky130_fd_sc_hd__decap_8
X_630_ _285_ net50 _284_ VGND VGND VPWR VPWR _036_ sky130_fd_sc_hd__and3b_1
X_492_ CLK_counter\[14\] _196_ VGND VGND VPWR VPWR _198_ sky130_fd_sc_hd__nand2_1
XFILLER_0_169 VGND VGND VPWR VPWR sky130_fd_sc_hd__fill_2
X_561_ net62 _093_ _237_ VGND VGND VPWR VPWR _243_ sky130_fd_sc_hd__or3_1
X_759_ clknet_3_7__leaf_CLK _056_ net75 VGND VGND VPWR VPWR CLK2_counter\[24\] sky130_fd_sc_hd__dfrtp_1
XFILLER_29_173 VGND VGND VPWR VPWR sky130_fd_sc_hd__fill_1
X_613_ _276_ net32 VGND VGND VPWR VPWR net33 sky130_fd_sc_hd__and2_1
X_544_ net64 _105_ VGND VGND VPWR VPWR _232_ sky130_fd_sc_hd__nand2_1
X_475_ CLK_counter\[8\] _184_ VGND VGND VPWR VPWR _187_ sky130_fd_sc_hd__or2_1
X_527_ CLK_counter\[26\] _218_ net49 VGND VGND VPWR VPWR _221_ sky130_fd_sc_hd__o21ai_1
XFILLER_17_110 VGND VGND VPWR VPWR sky130_fd_sc_hd__fill_2
XFILLER_1_220 VGND VGND VPWR VPWR sky130_fd_sc_hd__fill_1
X_389_ password\[1\] _083_ password\[7\] _087_ _112_ VGND VGND VPWR VPWR _113_ sky130_fd_sc_hd__o221ai_1
X_458_ CLK_counter\[1\] CLK_counter\[0\] CLK_counter\[3\] CLK_counter\[2\] VGND VGND
+ VPWR VPWR _175_ sky130_fd_sc_hd__and4_1
XTAP_TAPCELL_ROW_33_196 VGND VPWR sky130_fd_sc_hd__tapvpwrvgnd_1
XFILLER_23_113 VPWR VGND VPWR VGND sky130_ef_sc_hd__decap_12
XFILLER_11_57 VGND VGND VPWR VPWR sky130_fd_sc_hd__fill_2
XFILLER_36_65 VPWR VGND VPWR VGND sky130_ef_sc_hd__decap_12
XTAP_TAPCELL_ROW_24_163 VGND VPWR sky130_fd_sc_hd__tapvpwrvgnd_1
XFILLER_14_168 VGND VGND VPWR VPWR sky130_fd_sc_hd__decap_8
XFILLER_14_124 VGND VGND VPWR VPWR sky130_fd_sc_hd__decap_4
XFILLER_20_138 VGND VGND VPWR VPWR sky130_fd_sc_hd__fill_2
X_792_ clknet_3_2__leaf_CLK _012_ net68 VGND VGND VPWR VPWR CLK_counter\[20\] sky130_fd_sc_hd__dfrtp_1
XTAP_TAPCELL_ROW_21_155 VGND VPWR sky130_fd_sc_hd__tapvpwrvgnd_1
XFILLER_11_138 VGND VGND VPWR VPWR sky130_fd_sc_hd__decap_6
XFILLER_3_91 VGND VGND VPWR VPWR sky130_fd_sc_hd__decap_3
XTAP_TAPCELL_ROW_35_203 VGND VPWR sky130_fd_sc_hd__tapvpwrvgnd_1
XTAP_TAPCELL_ROW_12_122 VGND VPWR sky130_fd_sc_hd__tapvpwrvgnd_1
XFILLER_10_193 VGND VGND VPWR VPWR sky130_fd_sc_hd__decap_3
XFILLER_10_182 VGND VGND VPWR VPWR sky130_fd_sc_hd__decap_8
XFILLER_6_197 VGND VGND VPWR VPWR sky130_fd_sc_hd__fill_2
XFILLER_17_45 VGND VGND VPWR VPWR sky130_fd_sc_hd__decap_8
XPHY_EDGE_ROW_9_Left_47 VGND VGND VPWR VPWR sky130_fd_sc_hd__decap_3
XFILLER_33_99 VPWR VGND VPWR VGND sky130_ef_sc_hd__decap_12
XFILLER_33_55 VGND VGND VPWR VPWR sky130_fd_sc_hd__fill_1
Xhold7 CLK_counter\[27\] VGND VGND VPWR VPWR net84 sky130_fd_sc_hd__dlygate4sd3_1
XFILLER_3_134 VGND VGND VPWR VPWR sky130_fd_sc_hd__fill_2
XFILLER_3_145 VGND VGND VPWR VPWR sky130_fd_sc_hd__fill_2
XFILLER_3_167 VGND VGND VPWR VPWR sky130_fd_sc_hd__fill_1
X_775_ clknet_3_0__leaf_CLK _025_ net65 VGND VGND VPWR VPWR CLK_counter\[3\] sky130_fd_sc_hd__dfrtp_1
XFILLER_28_33 VPWR VGND VPWR VGND sky130_ef_sc_hd__decap_12
X_491_ _196_ _197_ VGND VGND VPWR VPWR _004_ sky130_fd_sc_hd__nor2_1
XFILLER_0_126 VGND VGND VPWR VPWR sky130_fd_sc_hd__decap_3
XFILLER_5_15 VGND VGND VPWR VPWR sky130_fd_sc_hd__decap_4
X_560_ net63 net30 VGND VGND VPWR VPWR _242_ sky130_fd_sc_hd__or2_1
X_758_ clknet_3_7__leaf_CLK _055_ net73 VGND VGND VPWR VPWR CLK2_counter\[23\] sky130_fd_sc_hd__dfrtp_1
X_689_ net51 _324_ _325_ VGND VGND VPWR VPWR _055_ sky130_fd_sc_hd__and3_1
XPHY_EDGE_ROW_22_Right_22 VGND VGND VPWR VPWR sky130_fd_sc_hd__decap_3
XPHY_EDGE_ROW_13_Right_13 VGND VGND VPWR VPWR sky130_fd_sc_hd__decap_3
XPHY_EDGE_ROW_31_Right_31 VGND VGND VPWR VPWR sky130_fd_sc_hd__decap_3
XFILLER_30_45 VPWR VGND VPWR VGND sky130_ef_sc_hd__decap_12
XFILLER_14_35 VGND VGND VPWR VPWR sky130_fd_sc_hd__fill_1
X_612_ attempt_count\[1\] attempt_count\[2\] _273_ VGND VGND VPWR VPWR net32 sky130_fd_sc_hd__a21oi_1
X_543_ net59 _091_ VGND VGND VPWR VPWR _231_ sky130_fd_sc_hd__nand2_1
X_474_ CLK_counter\[8\] _184_ VGND VGND VPWR VPWR _186_ sky130_fd_sc_hd__nand2_1
XFILLER_35_111 VGND VGND VPWR VPWR sky130_fd_sc_hd__fill_1
X_526_ CLK_counter\[26\] _218_ VGND VGND VPWR VPWR _220_ sky130_fd_sc_hd__and2_1
XFILLER_25_89 VGND VGND VPWR VPWR sky130_fd_sc_hd__decap_3
XFILLER_17_144 VGND VGND VPWR VPWR sky130_fd_sc_hd__decap_4
XFILLER_23_147 VGND VGND VPWR VPWR sky130_fd_sc_hd__fill_1
XFILLER_23_125 VGND VGND VPWR VPWR sky130_fd_sc_hd__decap_8
X_457_ _173_ _174_ net47 VGND VGND VPWR VPWR _022_ sky130_fd_sc_hd__and3b_1
X_388_ password\[0\] net6 VGND VGND VPWR VPWR _112_ sky130_fd_sc_hd__xnor2_1
XFILLER_36_77 VGND VGND VPWR VPWR sky130_fd_sc_hd__decap_6
XTAP_TAPCELL_ROW_33_197 VGND VPWR sky130_fd_sc_hd__tapvpwrvgnd_1
XTAP_TAPCELL_ROW_24_164 VGND VPWR sky130_fd_sc_hd__tapvpwrvgnd_1
X_509_ _208_ _209_ VGND VGND VPWR VPWR _010_ sky130_fd_sc_hd__nor2_1
XFILLER_22_57 VGND VGND VPWR VPWR sky130_fd_sc_hd__decap_3
XFILLER_11_106 VGND VGND VPWR VPWR sky130_fd_sc_hd__fill_2
XFILLER_34_209 VPWR VGND VPWR VGND sky130_ef_sc_hd__decap_12
X_791_ clknet_3_2__leaf_CLK _010_ net68 VGND VGND VPWR VPWR CLK_counter\[19\] sky130_fd_sc_hd__dfrtp_1
XTAP_TAPCELL_ROW_12_123 VGND VPWR sky130_fd_sc_hd__tapvpwrvgnd_1
XFILLER_10_172 VGND VGND VPWR VPWR sky130_fd_sc_hd__fill_1
XFILLER_6_121 VGND VGND VPWR VPWR sky130_fd_sc_hd__fill_1
XFILLER_8_37 VGND VGND VPWR VPWR sky130_fd_sc_hd__decap_4
XTAP_TAPCELL_ROW_35_204 VGND VPWR sky130_fd_sc_hd__tapvpwrvgnd_1
XPHY_EDGE_ROW_25_Left_63 VGND VGND VPWR VPWR sky130_fd_sc_hd__decap_3
XFILLER_17_57 VPWR VGND VPWR VGND sky130_ef_sc_hd__decap_12
X_774_ clknet_3_1__leaf_CLK _022_ net67 VGND VGND VPWR VPWR CLK_counter\[2\] sky130_fd_sc_hd__dfrtp_1
XFILLER_3_113 VGND VGND VPWR VPWR sky130_fd_sc_hd__decap_4
Xhold8 password\[2\] VGND VGND VPWR VPWR net85 sky130_fd_sc_hd__dlygate4sd3_1
XFILLER_31_3 VPWR VGND VPWR VGND sky130_ef_sc_hd__decap_12
XFILLER_21_201 VGND VGND VPWR VPWR sky130_fd_sc_hd__decap_6
XFILLER_28_45 VGND VGND VPWR VPWR sky130_fd_sc_hd__decap_4
X_490_ net96 _194_ net47 VGND VGND VPWR VPWR _197_ sky130_fd_sc_hd__o21ai_1
XFILLER_0_105 VGND VGND VPWR VPWR sky130_fd_sc_hd__decap_3
X_688_ CLK2_counter\[23\] _323_ VGND VGND VPWR VPWR _325_ sky130_fd_sc_hd__nand2_1
X_757_ clknet_3_7__leaf_CLK _054_ net73 VGND VGND VPWR VPWR CLK2_counter\[22\] sky130_fd_sc_hd__dfrtp_1
XFILLER_30_57 VGND VGND VPWR VPWR sky130_fd_sc_hd__fill_1
XPHY_EDGE_ROW_12_Left_50 VGND VGND VPWR VPWR sky130_fd_sc_hd__decap_3
XFILLER_29_120 VPWR VGND VPWR VGND sky130_ef_sc_hd__decap_12
X_542_ net93 _228_ _230_ net50 VGND VGND VPWR VPWR _024_ sky130_fd_sc_hd__o211a_1
X_611_ _273_ _275_ VGND VGND VPWR VPWR net46 sky130_fd_sc_hd__nor2_1
X_473_ _184_ _185_ VGND VGND VPWR VPWR _029_ sky130_fd_sc_hd__nor2_1
XFILLER_35_167 VGND VGND VPWR VPWR sky130_fd_sc_hd__fill_1
X_809_ clknet_3_4__leaf_CLK _074_ net72 VGND VGND VPWR VPWR password\[5\] sky130_fd_sc_hd__dfrtp_1
XFILLER_9_3 VPWR VGND VPWR VGND sky130_ef_sc_hd__decap_12
X_525_ net80 _217_ _219_ VGND VGND VPWR VPWR _017_ sky130_fd_sc_hd__o21a_1
X_456_ CLK_counter\[1\] CLK_counter\[0\] CLK_counter\[2\] VGND VGND VPWR VPWR _174_
+ sky130_fd_sc_hd__a21o_1
X_387_ net3 _090_ _092_ _110_ VGND VGND VPWR VPWR _111_ sky130_fd_sc_hd__a2bb2o_1
XFILLER_31_181 VGND VGND VPWR VPWR sky130_fd_sc_hd__fill_2
XTAP_TAPCELL_ROW_24_165 VGND VPWR sky130_fd_sc_hd__tapvpwrvgnd_1
X_508_ net92 _206_ net50 VGND VGND VPWR VPWR _209_ sky130_fd_sc_hd__o21ai_1
X_439_ CLK_counter\[17\] CLK_counter\[16\] CLK_counter\[19\] CLK_counter\[18\] VGND
+ VGND VPWR VPWR _159_ sky130_fd_sc_hd__or4_1
XTAP_TAPCELL_ROW_15_132 VGND VPWR sky130_fd_sc_hd__tapvpwrvgnd_1
X_790_ clknet_3_2__leaf_CLK _009_ net68 VGND VGND VPWR VPWR CLK_counter\[18\] sky130_fd_sc_hd__dfrtp_1
XFILLER_19_218 VGND VGND VPWR VPWR sky130_fd_sc_hd__decap_3
XTAP_TAPCELL_ROW_12_124 VGND VPWR sky130_fd_sc_hd__tapvpwrvgnd_1
XTAP_TAPCELL_ROW_6_100 VGND VPWR sky130_fd_sc_hd__tapvpwrvgnd_1
XFILLER_33_68 VGND VGND VPWR VPWR sky130_fd_sc_hd__fill_1
Xhold9 CLK_counter\[20\] VGND VGND VPWR VPWR net86 sky130_fd_sc_hd__dlygate4sd3_1
XFILLER_17_69 VPWR VGND VPWR VGND sky130_ef_sc_hd__decap_12
XFILLER_24_3 VPWR VGND VPWR VGND sky130_ef_sc_hd__decap_12
X_773_ clknet_3_0__leaf_CLK _011_ net65 VGND VGND VPWR VPWR CLK_counter\[1\] sky130_fd_sc_hd__dfrtp_1
XFILLER_9_92 VGND VGND VPWR VPWR sky130_fd_sc_hd__fill_1
X_687_ CLK2_counter\[23\] _323_ VGND VGND VPWR VPWR _324_ sky130_fd_sc_hd__or2_1
X_756_ clknet_3_7__leaf_CLK _053_ net73 VGND VGND VPWR VPWR CLK2_counter\[21\] sky130_fd_sc_hd__dfrtp_1
XFILLER_14_59 VGND VGND VPWR VPWR sky130_fd_sc_hd__fill_1
XFILLER_14_15 VPWR VGND VPWR VGND sky130_ef_sc_hd__decap_12
XPHY_EDGE_ROW_7_Right_7 VGND VGND VPWR VPWR sky130_fd_sc_hd__decap_3
XFILLER_29_154 VPWR VGND VPWR VGND sky130_ef_sc_hd__decap_12
XFILLER_29_132 VPWR VGND VPWR VGND sky130_ef_sc_hd__decap_12
XFILLER_29_110 VGND VGND VPWR VPWR sky130_fd_sc_hd__fill_2
X_541_ CLK_counter\[31\] _228_ VGND VGND VPWR VPWR _230_ sky130_fd_sc_hd__nand2_1
X_610_ _273_ _277_ VGND VGND VPWR VPWR net44 sky130_fd_sc_hd__nand2_1
X_472_ net89 _181_ net47 VGND VGND VPWR VPWR _185_ sky130_fd_sc_hd__o21ai_1
XFILLER_35_113 VPWR VGND VPWR VGND sky130_ef_sc_hd__decap_12
X_739_ clknet_3_2__leaf_CLK _036_ net69 VGND VGND VPWR VPWR CLK2_counter\[4\] sky130_fd_sc_hd__dfrtp_1
XFILLER_4_220 VGND VGND VPWR VPWR sky130_fd_sc_hd__fill_1
X_808_ clknet_3_4__leaf_CLK _073_ net71 VGND VGND VPWR VPWR password\[4\] sky130_fd_sc_hd__dfstp_1
X_524_ _218_ net49 VGND VGND VPWR VPWR _219_ sky130_fd_sc_hd__and2b_1
XTAP_TAPCELL_ROW_27_174 VGND VPWR sky130_fd_sc_hd__tapvpwrvgnd_1
XFILLER_17_113 VGND VGND VPWR VPWR sky130_fd_sc_hd__fill_1
X_386_ _098_ _109_ VGND VGND VPWR VPWR _110_ sky130_fd_sc_hd__nor2_1
X_455_ CLK_counter\[1\] CLK_counter\[0\] CLK_counter\[2\] VGND VGND VPWR VPWR _173_
+ sky130_fd_sc_hd__and3_1
XTAP_TAPCELL_ROW_24_166 VGND VPWR sky130_fd_sc_hd__tapvpwrvgnd_1
XFILLER_14_138 VGND VGND VPWR VPWR sky130_fd_sc_hd__fill_2
X_438_ CLK_counter\[21\] CLK_counter\[20\] CLK_counter\[23\] CLK_counter\[22\] VGND
+ VGND VPWR VPWR _158_ sky130_fd_sc_hd__or4_1
Xwire56 _162_ VGND VGND VPWR VPWR net56 sky130_fd_sc_hd__clkbuf_1
X_507_ CLK_counter\[19\] CLK_counter\[18\] _201_ _204_ VGND VGND VPWR VPWR _208_ sky130_fd_sc_hd__and4_1
XTAP_TAPCELL_ROW_15_133 VGND VPWR sky130_fd_sc_hd__tapvpwrvgnd_1
XFILLER_9_186 VPWR VGND VPWR VGND sky130_ef_sc_hd__decap_12
X_369_ net59 _091_ VGND VGND VPWR VPWR _093_ sky130_fd_sc_hd__or2_1
XFILLER_10_141 VGND VGND VPWR VPWR sky130_fd_sc_hd__fill_2
XFILLER_10_130 VGND VGND VPWR VPWR sky130_fd_sc_hd__fill_2
XTAP_TAPCELL_ROW_6_101 VGND VPWR sky130_fd_sc_hd__tapvpwrvgnd_1
XFILLER_6_112 VGND VGND VPWR VPWR sky130_fd_sc_hd__fill_1
XFILLER_15_211 VGND VGND VPWR VPWR sky130_fd_sc_hd__fill_2
X_772_ clknet_3_0__leaf_CLK _000_ net65 VGND VGND VPWR VPWR CLK_counter\[0\] sky130_fd_sc_hd__dfrtp_1
XFILLER_28_69 VGND VGND VPWR VPWR sky130_fd_sc_hd__fill_2
X_755_ clknet_3_7__leaf_CLK _052_ net73 VGND VGND VPWR VPWR CLK2_counter\[20\] sky130_fd_sc_hd__dfrtp_1
X_686_ _323_ net52 _322_ VGND VGND VPWR VPWR _054_ sky130_fd_sc_hd__and3b_1
XFILLER_30_37 VGND VGND VPWR VPWR sky130_fd_sc_hd__fill_1
XFILLER_29_166 VGND VGND VPWR VPWR sky130_fd_sc_hd__fill_2
XFILLER_29_144 VGND VGND VPWR VPWR sky130_fd_sc_hd__decap_4
X_540_ _228_ _229_ VGND VGND VPWR VPWR _023_ sky130_fd_sc_hd__nor2_1
XFILLER_14_27 VGND VGND VPWR VPWR sky130_fd_sc_hd__fill_1
X_471_ CLK_counter\[5\] CLK_counter\[4\] _175_ _183_ VGND VGND VPWR VPWR _184_ sky130_fd_sc_hd__and4_1
XFILLER_35_169 VPWR VGND VPWR VGND sky130_ef_sc_hd__decap_12
XFILLER_35_125 VPWR VGND VPWR VGND sky130_ef_sc_hd__decap_12
X_669_ CLK2_counter\[15\] CLK2_counter\[14\] _303_ _311_ VGND VGND VPWR VPWR _312_
+ sky130_fd_sc_hd__and4_2
X_738_ clknet_3_1__leaf_CLK _035_ net67 VGND VGND VPWR VPWR CLK2_counter\[3\] sky130_fd_sc_hd__dfrtp_1
X_807_ clknet_3_4__leaf_CLK _072_ net72 VGND VGND VPWR VPWR password\[3\] sky130_fd_sc_hd__dfstp_1
XFILLER_26_169 VGND VGND VPWR VPWR sky130_fd_sc_hd__fill_2
XFILLER_25_48 VGND VGND VPWR VPWR sky130_fd_sc_hd__fill_1
XFILLER_6_83 VGND VGND VPWR VPWR sky130_fd_sc_hd__fill_1
XFILLER_31_80 VGND VGND VPWR VPWR sky130_fd_sc_hd__decap_6
X_523_ CLK_counter\[23\] CLK_counter\[25\] CLK_counter\[24\] _214_ VGND VGND VPWR
+ VPWR _218_ sky130_fd_sc_hd__and4_1
XTAP_TAPCELL_ROW_27_175 VGND VPWR sky130_fd_sc_hd__tapvpwrvgnd_1
X_385_ _077_ _104_ _107_ _108_ VGND VGND VPWR VPWR _109_ sky130_fd_sc_hd__or4_1
X_454_ CLK_counter\[1\] CLK_counter\[0\] _172_ VGND VGND VPWR VPWR _011_ sky130_fd_sc_hd__o21a_1
XTAP_TAPCELL_ROW_18_142 VGND VPWR sky130_fd_sc_hd__tapvpwrvgnd_1
XFILLER_37_209 VPWR VGND VPWR VGND sky130_ef_sc_hd__decap_12
XFILLER_14_128 VGND VGND VPWR VPWR sky130_fd_sc_hd__fill_1
XFILLER_28_209 VPWR VGND VPWR VGND sky130_ef_sc_hd__decap_12
X_506_ _206_ _207_ VGND VGND VPWR VPWR _009_ sky130_fd_sc_hd__nor2_1
XTAP_TAPCELL_ROW_15_134 VGND VPWR sky130_fd_sc_hd__tapvpwrvgnd_1
X_437_ _082_ _123_ _139_ _156_ VGND VGND VPWR VPWR _157_ sky130_fd_sc_hd__o211a_1
XFILLER_9_198 VPWR VGND VPWR VGND sky130_ef_sc_hd__decap_12
XFILLER_9_143 VGND VGND VPWR VPWR sky130_fd_sc_hd__fill_1
X_368_ net59 _091_ VGND VGND VPWR VPWR _092_ sky130_fd_sc_hd__nor2_1
XPHY_EDGE_ROW_29_Right_29 VGND VGND VPWR VPWR sky130_fd_sc_hd__decap_3
XTAP_TAPCELL_ROW_6_102 VGND VPWR sky130_fd_sc_hd__tapvpwrvgnd_1
XFILLER_19_7 VPWR VGND VPWR VGND sky130_ef_sc_hd__decap_12
XFILLER_12_93 VGND VGND VPWR VPWR sky130_fd_sc_hd__decap_3
XFILLER_10_197 VPWR VGND VPWR VGND sky130_ef_sc_hd__decap_12
XFILLER_33_15 VPWR VGND VPWR VGND sky130_ef_sc_hd__decap_12
XPHY_EDGE_ROW_29_Left_67 VGND VGND VPWR VPWR sky130_fd_sc_hd__decap_3
X_771_ clknet_3_7__leaf_CLK _068_ net73 VGND VGND VPWR VPWR attempt_count\[4\] sky130_fd_sc_hd__dfrtp_2
XFILLER_9_72 VGND VGND VPWR VPWR sky130_fd_sc_hd__decap_4
XFILLER_0_85 VGND VGND VPWR VPWR sky130_fd_sc_hd__fill_2
XFILLER_0_41 VPWR VGND VPWR VGND sky130_ef_sc_hd__decap_12
XFILLER_28_26 VGND VGND VPWR VPWR sky130_fd_sc_hd__fill_2
XFILLER_28_15 VGND VGND VPWR VPWR sky130_fd_sc_hd__decap_4
XFILLER_0_119 VGND VGND VPWR VPWR sky130_fd_sc_hd__decap_3
XFILLER_5_19 VGND VGND VPWR VPWR sky130_fd_sc_hd__fill_1
X_685_ CLK2_counter\[22\] _312_ _316_ _320_ VGND VGND VPWR VPWR _323_ sky130_fd_sc_hd__and4_1
X_754_ clknet_3_7__leaf_CLK _051_ net73 VGND VGND VPWR VPWR CLK2_counter\[19\] sky130_fd_sc_hd__dfrtp_1
XFILLER_18_81 VGND VGND VPWR VPWR sky130_fd_sc_hd__decap_3
XFILLER_29_189 VPWR VGND VPWR VGND sky130_ef_sc_hd__decap_12
XFILLER_35_137 VPWR VGND VPWR VGND sky130_ef_sc_hd__decap_12
X_668_ CLK2_counter\[17\] CLK2_counter\[16\] VGND VGND VPWR VPWR _311_ sky130_fd_sc_hd__and2_1
X_599_ _273_ VGND VGND VPWR VPWR net45 sky130_fd_sc_hd__inv_2
X_737_ clknet_3_1__leaf_CLK _034_ net67 VGND VGND VPWR VPWR CLK2_counter\[2\] sky130_fd_sc_hd__dfrtp_1
X_470_ CLK_counter\[7\] CLK_counter\[6\] VGND VGND VPWR VPWR _183_ sky130_fd_sc_hd__and2_1
X_806_ clknet_3_4__leaf_CLK _071_ net71 VGND VGND VPWR VPWR password\[2\] sky130_fd_sc_hd__dfrtp_1
XFILLER_26_137 VGND VGND VPWR VPWR sky130_fd_sc_hd__decap_3
XPHY_EDGE_ROW_16_Left_54 VGND VGND VPWR VPWR sky130_fd_sc_hd__decap_3
X_522_ _217_ net49 _216_ VGND VGND VPWR VPWR _016_ sky130_fd_sc_hd__and3b_1
XTAP_TAPCELL_ROW_27_176 VGND VPWR sky130_fd_sc_hd__tapvpwrvgnd_1
X_384_ CLK2_counter\[6\] CLK2_counter\[4\] CLK2_counter\[5\] CLK2_counter\[7\] VGND
+ VGND VPWR VPWR _108_ sky130_fd_sc_hd__or4b_1
X_453_ CLK_counter\[1\] CLK_counter\[0\] net47 VGND VGND VPWR VPWR _172_ sky130_fd_sc_hd__a21boi_1
XTAP_TAPCELL_ROW_18_143 VGND VPWR sky130_fd_sc_hd__tapvpwrvgnd_1
XFILLER_36_15 VPWR VGND VPWR VGND sky130_ef_sc_hd__decap_12
XFILLER_22_195 VGND VGND VPWR VPWR sky130_fd_sc_hd__fill_1
XTAP_TAPCELL_ROW_9_111 VGND VPWR sky130_fd_sc_hd__tapvpwrvgnd_1
XPHY_EDGE_ROW_1_Left_39 VGND VGND VPWR VPWR sky130_fd_sc_hd__decap_3
X_505_ net95 _205_ net50 VGND VGND VPWR VPWR _207_ sky130_fd_sc_hd__o21ai_1
X_436_ state\[0\] next_state\[0\] VGND VGND VPWR VPWR _156_ sky130_fd_sc_hd__xnor2_1
XFILLER_9_111 VGND VGND VPWR VPWR sky130_fd_sc_hd__fill_1
X_367_ net60 net58 VGND VGND VPWR VPWR _091_ sky130_fd_sc_hd__nand2b_1
XFILLER_3_30 VGND VGND VPWR VPWR sky130_fd_sc_hd__decap_6
XTAP_TAPCELL_ROW_6_103 VGND VPWR sky130_fd_sc_hd__tapvpwrvgnd_1
XFILLER_18_210 VGND VGND VPWR VPWR sky130_fd_sc_hd__fill_1
XFILLER_12_83 VGND VGND VPWR VPWR sky130_fd_sc_hd__fill_1
XFILLER_10_110 VGND VGND VPWR VPWR sky130_fd_sc_hd__decap_3
XFILLER_6_103 VGND VGND VPWR VPWR sky130_fd_sc_hd__fill_1
X_419_ net9 net11 net13 net7 VGND VGND VPWR VPWR _141_ sky130_fd_sc_hd__a2bb2o_1
XFILLER_33_27 VGND VGND VPWR VPWR sky130_fd_sc_hd__decap_8
X_770_ clknet_3_7__leaf_CLK _067_ net73 VGND VGND VPWR VPWR attempt_count\[3\] sky130_fd_sc_hd__dfrtp_2
XFILLER_3_117 VGND VGND VPWR VPWR sky130_fd_sc_hd__fill_1
XPHY_EDGE_ROW_4_Left_42 VGND VGND VPWR VPWR sky130_fd_sc_hd__decap_3
XFILLER_9_84 VGND VGND VPWR VPWR sky130_fd_sc_hd__fill_1
XFILLER_0_53 VGND VGND VPWR VPWR sky130_fd_sc_hd__decap_3
XFILLER_2_161 VGND VGND VPWR VPWR sky130_fd_sc_hd__decap_4
XFILLER_2_194 VGND VGND VPWR VPWR sky130_fd_sc_hd__fill_2
XPHY_EDGE_ROW_30_Left_68 VGND VGND VPWR VPWR sky130_fd_sc_hd__decap_3
X_684_ CLK2_counter\[22\] _321_ VGND VGND VPWR VPWR _322_ sky130_fd_sc_hd__or2_1
X_753_ clknet_3_6__leaf_CLK _050_ net73 VGND VGND VPWR VPWR CLK2_counter\[18\] sky130_fd_sc_hd__dfrtp_1
Xclkbuf_3_3__f_CLK clknet_0_CLK VGND VGND VPWR VPWR clknet_3_3__leaf_CLK sky130_fd_sc_hd__clkbuf_16
XFILLER_22_3 VGND VGND VPWR VPWR sky130_fd_sc_hd__decap_8
XFILLER_14_29 VGND VGND VPWR VPWR sky130_fd_sc_hd__decap_6
XFILLER_29_81 VPWR VGND VPWR VGND sky130_ef_sc_hd__decap_12
XFILLER_20_83 VGND VGND VPWR VPWR sky130_fd_sc_hd__fill_1
X_805_ clknet_3_5__leaf_CLK _070_ net71 VGND VGND VPWR VPWR password\[1\] sky130_fd_sc_hd__dfrtp_1
X_736_ clknet_3_1__leaf_CLK _033_ net67 VGND VGND VPWR VPWR CLK2_counter\[1\] sky130_fd_sc_hd__dfrtp_1
XFILLER_35_149 VPWR VGND VPWR VGND sky130_ef_sc_hd__decap_12
XFILLER_35_105 VGND VGND VPWR VPWR sky130_fd_sc_hd__decap_6
X_667_ CLK2_counter\[16\] _307_ CLK2_counter\[17\] VGND VGND VPWR VPWR _310_ sky130_fd_sc_hd__a21o_1
X_598_ attempt_count\[4\] attempt_count\[3\] VGND VGND VPWR VPWR _273_ sky130_fd_sc_hd__or2_2
XFILLER_32_108 VPWR VGND VPWR VGND sky130_ef_sc_hd__decap_12
X_521_ CLK_counter\[23\] CLK_counter\[24\] _214_ VGND VGND VPWR VPWR _217_ sky130_fd_sc_hd__and3_1
XFILLER_17_127 VGND VGND VPWR VPWR sky130_fd_sc_hd__decap_3
X_452_ CLK_counter\[0\] _171_ VGND VGND VPWR VPWR _000_ sky130_fd_sc_hd__and2b_1
X_383_ _078_ _106_ VGND VGND VPWR VPWR _107_ sky130_fd_sc_hd__nand2_1
XPHY_EDGE_ROW_33_Left_71 VGND VGND VPWR VPWR sky130_fd_sc_hd__decap_3
XTAP_TAPCELL_ROW_18_144 VGND VPWR sky130_fd_sc_hd__tapvpwrvgnd_1
X_719_ attempt_count\[1\] _343_ VGND VGND VPWR VPWR _346_ sky130_fd_sc_hd__nor2_1
XTAP_TAPCELL_ROW_2_86 VGND VPWR sky130_fd_sc_hd__tapvpwrvgnd_1
XFILLER_36_27 VGND VGND VPWR VPWR sky130_fd_sc_hd__fill_1
XTAP_TAPCELL_ROW_32_191 VGND VPWR sky130_fd_sc_hd__tapvpwrvgnd_1
X_504_ CLK_counter\[18\] _201_ _204_ VGND VGND VPWR VPWR _206_ sky130_fd_sc_hd__and3_1
XFILLER_13_152 VGND VGND VPWR VPWR sky130_fd_sc_hd__decap_3
X_435_ _155_ VGND VGND VPWR VPWR net15 sky130_fd_sc_hd__inv_2
XTAP_TAPCELL_ROW_9_112 VGND VPWR sky130_fd_sc_hd__tapvpwrvgnd_1
X_366_ net58 net4 net60 net59 VGND VGND VPWR VPWR _090_ sky130_fd_sc_hd__or4bb_1
XFILLER_3_64 VPWR VGND VPWR VGND sky130_ef_sc_hd__decap_12
XTAP_TAPCELL_ROW_20_150 VGND VPWR sky130_fd_sc_hd__tapvpwrvgnd_1
XFILLER_6_137 VGND VGND VPWR VPWR sky130_fd_sc_hd__decap_3
XFILLER_37_81 VGND VGND VPWR VPWR sky130_fd_sc_hd__decap_3
X_418_ net58 net3 net60 net59 VGND VGND VPWR VPWR _140_ sky130_fd_sc_hd__and4b_1
XFILLER_0_98 VGND VGND VPWR VPWR sky130_fd_sc_hd__decap_3
X_683_ _321_ net51 _319_ VGND VGND VPWR VPWR _053_ sky130_fd_sc_hd__and3b_1
X_752_ clknet_3_6__leaf_CLK _049_ net74 VGND VGND VPWR VPWR CLK2_counter\[17\] sky130_fd_sc_hd__dfrtp_1
XTAP_TAPCELL_ROW_5_97 VGND VPWR sky130_fd_sc_hd__tapvpwrvgnd_1
XFILLER_29_169 VGND VGND VPWR VPWR sky130_fd_sc_hd__decap_4
XFILLER_20_40 VGND VGND VPWR VPWR sky130_fd_sc_hd__decap_4
XFILLER_29_93 VGND VGND VPWR VPWR sky130_fd_sc_hd__decap_6
X_666_ net51 _308_ _309_ VGND VGND VPWR VPWR _048_ sky130_fd_sc_hd__and3_1
X_597_ _106_ _272_ _271_ _270_ VGND VGND VPWR VPWR net22 sky130_fd_sc_hd__o211a_1
XFILLER_6_64 VGND VGND VPWR VPWR sky130_fd_sc_hd__decap_3
X_735_ clknet_3_1__leaf_CLK _032_ net67 VGND VGND VPWR VPWR CLK2_counter\[0\] sky130_fd_sc_hd__dfrtp_4
X_804_ clknet_3_5__leaf_CLK _069_ net71 VGND VGND VPWR VPWR password\[0\] sky130_fd_sc_hd__dfstp_1
X_520_ CLK_counter\[23\] _214_ CLK_counter\[24\] VGND VGND VPWR VPWR _216_ sky130_fd_sc_hd__a21o_1
XFILLER_23_109 VGND VGND VPWR VPWR sky130_fd_sc_hd__decap_3
XTAP_TAPCELL_ROW_18_145 VGND VPWR sky130_fd_sc_hd__tapvpwrvgnd_1
X_649_ CLK2_counter\[11\] _296_ VGND VGND VPWR VPWR _298_ sky130_fd_sc_hd__nor2_1
XFILLER_15_62 VGND VGND VPWR VPWR sky130_fd_sc_hd__decap_8
X_718_ attempt_count\[1\] _343_ VGND VGND VPWR VPWR _345_ sky130_fd_sc_hd__and2_1
X_451_ _170_ net47 VGND VGND VPWR VPWR _171_ sky130_fd_sc_hd__and2b_2
X_382_ CLK2_counter\[1\] CLK2_counter\[0\] VGND VGND VPWR VPWR _106_ sky130_fd_sc_hd__nor2_2
XTAP_TAPCELL_ROW_2_87 VGND VPWR sky130_fd_sc_hd__tapvpwrvgnd_1
XFILLER_16_194 VGND VGND VPWR VPWR sky130_fd_sc_hd__fill_2
XTAP_TAPCELL_ROW_32_192 VGND VPWR sky130_fd_sc_hd__tapvpwrvgnd_1
XFILLER_26_83 VGND VGND VPWR VPWR sky130_fd_sc_hd__fill_1
XFILLER_26_50 VGND VGND VPWR VPWR sky130_fd_sc_hd__decap_8
X_503_ _203_ _205_ net50 VGND VGND VPWR VPWR _008_ sky130_fd_sc_hd__nor3b_1
XFILLER_22_197 VPWR VGND VPWR VGND sky130_ef_sc_hd__decap_12
XFILLER_13_197 VGND VGND VPWR VPWR sky130_fd_sc_hd__fill_2
X_434_ CLK2_counter\[9\] _154_ _133_ VGND VGND VPWR VPWR _155_ sky130_fd_sc_hd__o21a_1
X_365_ net30 VGND VGND VPWR VPWR net29 sky130_fd_sc_hd__inv_2
XTAP_TAPCELL_ROW_9_113 VGND VPWR sky130_fd_sc_hd__tapvpwrvgnd_1
XFILLER_9_113 VPWR VGND VPWR VGND sky130_ef_sc_hd__decap_12
XFILLER_3_43 VGND VGND VPWR VPWR sky130_fd_sc_hd__fill_2
XFILLER_3_76 VGND VGND VPWR VPWR sky130_fd_sc_hd__decap_3
XTAP_TAPCELL_ROW_20_151 VGND VPWR sky130_fd_sc_hd__tapvpwrvgnd_1
XFILLER_12_85 VGND VGND VPWR VPWR sky130_fd_sc_hd__decap_8
XPHY_EDGE_ROW_25_Right_25 VGND VGND VPWR VPWR sky130_fd_sc_hd__decap_3
XPHY_EDGE_ROW_16_Right_16 VGND VGND VPWR VPWR sky130_fd_sc_hd__decap_3
X_417_ _098_ _135_ _138_ VGND VGND VPWR VPWR _139_ sky130_fd_sc_hd__or3_1
XPHY_EDGE_ROW_34_Right_34 VGND VGND VPWR VPWR sky130_fd_sc_hd__decap_3
XFILLER_17_7 VGND VGND VPWR VPWR sky130_fd_sc_hd__fill_2
XFILLER_0_77 VGND VGND VPWR VPWR sky130_fd_sc_hd__decap_3
XFILLER_9_31 VGND VGND VPWR VPWR sky130_fd_sc_hd__fill_1
X_682_ _312_ _316_ _320_ VGND VGND VPWR VPWR _321_ sky130_fd_sc_hd__and3_1
X_751_ clknet_3_6__leaf_CLK _048_ net74 VGND VGND VPWR VPWR CLK2_counter\[16\] sky130_fd_sc_hd__dfrtp_1
XFILLER_18_62 VGND VGND VPWR VPWR sky130_fd_sc_hd__fill_2
XFILLER_34_83 VGND VGND VPWR VPWR sky130_fd_sc_hd__fill_1
XTAP_TAPCELL_ROW_5_98 VGND VPWR sky130_fd_sc_hd__tapvpwrvgnd_1
XFILLER_37_181 VPWR VGND VPWR VGND sky130_ef_sc_hd__decap_12
XPHY_EDGE_ROW_2_Right_2 VGND VGND VPWR VPWR sky130_fd_sc_hd__decap_3
X_665_ CLK2_counter\[16\] _307_ VGND VGND VPWR VPWR _309_ sky130_fd_sc_hd__nand2_1
X_803_ clknet_3_2__leaf_CLK net94 net68 VGND VGND VPWR VPWR CLK_counter\[31\] sky130_fd_sc_hd__dfrtp_1
XFILLER_20_85 VGND VGND VPWR VPWR sky130_fd_sc_hd__fill_1
X_596_ net63 _123_ _237_ _244_ VGND VGND VPWR VPWR _272_ sky130_fd_sc_hd__o22a_1
X_734_ net13 password\[7\] _349_ VGND VGND VPWR VPWR _076_ sky130_fd_sc_hd__mux2_1
XFILLER_6_43 VGND VGND VPWR VPWR sky130_fd_sc_hd__fill_1
XFILLER_34_195 VGND VGND VPWR VPWR sky130_fd_sc_hd__fill_1
Xoutput40 net40 VGND VGND VPWR VPWR LED[3] sky130_fd_sc_hd__buf_2
X_450_ net54 _169_ VGND VGND VPWR VPWR _170_ sky130_fd_sc_hd__and2_1
XTAP_TAPCELL_ROW_2_88 VGND VPWR sky130_fd_sc_hd__tapvpwrvgnd_1
X_381_ net62 CLK2_counter\[0\] VGND VGND VPWR VPWR _105_ sky130_fd_sc_hd__nor2_1
XFILLER_36_29 VPWR VGND VPWR VGND sky130_ef_sc_hd__decap_12
X_648_ _296_ _297_ VGND VGND VPWR VPWR _042_ sky130_fd_sc_hd__nor2_1
XFILLER_16_173 VPWR VGND VPWR VGND sky130_ef_sc_hd__decap_12
X_717_ _343_ _344_ VGND VGND VPWR VPWR _064_ sky130_fd_sc_hd__nor2_1
X_579_ net62 CLK2_counter\[0\] _091_ _237_ _244_ VGND VGND VPWR VPWR _258_ sky130_fd_sc_hd__o32a_1
XTAP_TAPCELL_ROW_32_193 VGND VPWR sky130_fd_sc_hd__tapvpwrvgnd_1
XFILLER_26_62 VGND VGND VPWR VPWR sky130_fd_sc_hd__decap_4
XFILLER_22_187 VGND VGND VPWR VPWR sky130_fd_sc_hd__decap_8
X_502_ _201_ _204_ VGND VGND VPWR VPWR _205_ sky130_fd_sc_hd__and2_1
X_433_ _153_ VGND VGND VPWR VPWR _154_ sky130_fd_sc_hd__inv_2
XTAP_TAPCELL_ROW_23_160 VGND VPWR sky130_fd_sc_hd__tapvpwrvgnd_1
X_364_ net60 _088_ VGND VGND VPWR VPWR net30 sky130_fd_sc_hd__or2_1
XFILLER_9_125 VPWR VGND VPWR VGND sky130_ef_sc_hd__decap_12
XFILLER_9_103 VGND VGND VPWR VPWR sky130_fd_sc_hd__decap_8
XFILLER_3_11 VGND VGND VPWR VPWR sky130_fd_sc_hd__fill_1
XFILLER_33_205 VPWR VGND VPWR VGND sky130_ef_sc_hd__decap_12
XTAP_TAPCELL_ROW_20_152 VGND VPWR sky130_fd_sc_hd__tapvpwrvgnd_1
X_416_ _102_ _107_ _136_ _137_ VGND VGND VPWR VPWR _138_ sky130_fd_sc_hd__or4_1
XFILLER_5_3 VPWR VGND VPWR VGND sky130_ef_sc_hd__decap_12
XTAP_TAPCELL_ROW_34_200 VGND VPWR sky130_fd_sc_hd__tapvpwrvgnd_1
XFILLER_28_19 VGND VGND VPWR VPWR sky130_fd_sc_hd__fill_1
XFILLER_9_76 VGND VGND VPWR VPWR sky130_fd_sc_hd__fill_1
X_681_ CLK2_counter\[21\] CLK2_counter\[20\] VGND VGND VPWR VPWR _320_ sky130_fd_sc_hd__and2_1
X_750_ clknet_3_6__leaf_CLK _047_ net74 VGND VGND VPWR VPWR CLK2_counter\[15\] sky130_fd_sc_hd__dfrtp_1
XPHY_EDGE_ROW_8_Left_46 VGND VGND VPWR VPWR sky130_fd_sc_hd__decap_3
XTAP_TAPCELL_ROW_5_99 VGND VPWR sky130_fd_sc_hd__tapvpwrvgnd_1
XFILLER_37_193 VGND VGND VPWR VPWR sky130_fd_sc_hd__decap_3
X_664_ CLK2_counter\[16\] _307_ VGND VGND VPWR VPWR _308_ sky130_fd_sc_hd__or2_1
X_802_ clknet_3_3__leaf_CLK _023_ net69 VGND VGND VPWR VPWR CLK_counter\[30\] sky130_fd_sc_hd__dfrtp_1
XFILLER_20_53 VPWR VGND VPWR VGND sky130_ef_sc_hd__decap_12
X_733_ net12 net83 _349_ VGND VGND VPWR VPWR _075_ sky130_fd_sc_hd__mux2_1
X_595_ net64 _093_ _234_ _252_ VGND VGND VPWR VPWR _271_ sky130_fd_sc_hd__o31a_1
XFILLER_34_141 VPWR VGND VPWR VGND sky130_ef_sc_hd__decap_12
XFILLER_6_88 VGND VGND VPWR VPWR sky130_fd_sc_hd__fill_1
XFILLER_25_174 VPWR VGND VPWR VGND sky130_ef_sc_hd__decap_12
X_380_ CLK2_counter\[10\] _103_ CLK2_counter\[11\] _101_ VGND VGND VPWR VPWR _104_
+ sky130_fd_sc_hd__or4b_1
Xoutput30 net30 VGND VGND VPWR VPWR LED16_R sky130_fd_sc_hd__buf_2
XTAP_TAPCELL_ROW_2_89 VGND VPWR sky130_fd_sc_hd__tapvpwrvgnd_1
Xoutput41 net41 VGND VGND VPWR VPWR LED[4] sky130_fd_sc_hd__buf_2
XFILLER_31_111 VGND VGND VPWR VPWR sky130_fd_sc_hd__fill_1
XFILLER_16_185 VGND VGND VPWR VPWR sky130_fd_sc_hd__decap_3
X_647_ CLK2_counter\[10\] _295_ net53 VGND VGND VPWR VPWR _297_ sky130_fd_sc_hd__o21ai_1
X_716_ net1 net57 net98 VGND VGND VPWR VPWR _344_ sky130_fd_sc_hd__a21oi_1
X_578_ _242_ _244_ _256_ _257_ VGND VGND VPWR VPWR net26 sky130_fd_sc_hd__and4_1
.ends
